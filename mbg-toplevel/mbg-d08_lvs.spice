* LVS source topology for mbg-d08.gds.
*
* The simulation modules in spice/ use X records because the GF180 model
* library exposes MOS devices as subcircuits.  KLayout LVS compares native
* MOS records, so this file is the LVS-normalized form of those same module
* topologies.  The pre-simulation deck remains mbg-d08_pre_sim.spice and
* directly includes the supplied files from spice/.

.subckt deepseek_ota VDD VSS INP INN OUT IBIAS
M1 net1 INP net2 VSS nfet_03v3 L=1u W=4u nf=4
M2 OUT INN net2 VSS nfet_03v3 L=1u W=4u nf=4
M3 net1 net1 VDD VDD pfet_03v3 L=1u W=2.4u nf=4
M4 OUT net1 VDD VDD pfet_03v3 L=1u W=2.4u nf=4
M5 net2 IBIAS VSS VSS nfet_03v3 L=1u W=8u nf=4
M6 IBIAS IBIAS VSS VSS nfet_03v3 L=1u W=4u nf=4
.ends deepseek_ota

.subckt gpt_luna_ota VDD VSS INP INN OUT IBIAS
M1 NLEFT INP NTAIL VSS nfet_03v3 L=0.6u W=4u nf=4
M2 OUT INN NTAIL VSS nfet_03v3 L=0.6u W=4u nf=4
M3 NLEFT NLEFT VDD VDD pfet_03v3 L=0.8u W=6u nf=4
M4 OUT NLEFT VDD VDD pfet_03v3 L=0.8u W=6u nf=4
M5 NTAIL IBIAS VSS VSS nfet_03v3 L=1u W=4u nf=4
M6 IBIAS IBIAS VSS VSS nfet_03v3 L=1u W=4u nf=4
.ends gpt_luna_ota

.subckt ox_alpha_ota VDD VSS INP INN OUT IBIAS
M1 IBIAS IBIAS VSS VSS nfet_03v3 W=2.0u L=2.0u nf=1
M2 tail IBIAS VSS VSS nfet_03v3 W=12.0u L=4.0u nf=2
M3 n1 INN tail VSS nfet_03v3 W=6.0u L=2.0u nf=1
M4 OUT INP tail VSS nfet_03v3 W=6.0u L=2.0u nf=1
M5 n1 n1 VDD VDD pfet_03v3 W=30.0u L=4.0u nf=4
M6 OUT n1 VDD VDD pfet_03v3 W=30.0u L=4.0u nf=4
.ends ox_alpha_ota

.subckt deepseek_strongarm_comparator VDD VSS INP INN CLK OUTP OUTN
M1 TAIL CLK VSS VSS nfet_03v3 L=0.5u W=2u nf=1
M2 D1 INP TAIL VSS nfet_03v3 L=0.6u W=16u nf=8
M3 D2 INN TAIL VSS nfet_03v3 L=0.6u W=16u nf=8
M4 OUTN OUTP D1 VSS nfet_03v3 L=0.5u W=6u nf=3
M5 OUTP OUTN D2 VSS nfet_03v3 L=0.5u W=6u nf=3
M6 OUTN OUTP VDD VDD pfet_03v3 L=0.5u W=6u nf=3
M7 OUTP OUTN VDD VDD pfet_03v3 L=0.5u W=6u nf=3
M8 OUTN CLK VDD VDD pfet_03v3 L=0.5u W=2u nf=1
M9 OUTP CLK VDD VDD pfet_03v3 L=0.5u W=2u nf=1
M10 D1 CLK VDD VDD pfet_03v3 L=0.5u W=2u nf=1
M11 D2 CLK VDD VDD pfet_03v3 L=0.5u W=2u nf=1
.ends deepseek_strongarm_comparator

.subckt gpt_luna_strongarm_comparator VDD VSS INP INN CLK OUTP OUTN
M1 TAIL CLK VSS VSS nfet_03v3 L=0.6u W=4u nf=4
M2 D1 INP TAIL VSS nfet_03v3 L=0.6u W=3u nf=3
M3 D2 INN TAIL VSS nfet_03v3 L=0.6u W=3u nf=3
M4 OUTN OUTP D1 VSS nfet_03v3 L=0.6u W=5u nf=5
M5 OUTP OUTN D2 VSS nfet_03v3 L=0.6u W=5u nf=5
M6 OUTN OUTP VDD VDD pfet_03v3 L=0.6u W=3u nf=3
M7 OUTP OUTN VDD VDD pfet_03v3 L=0.6u W=3u nf=3
M8 OUTN CLK VDD VDD pfet_03v3 L=0.6u W=3u nf=3
M9 OUTP CLK VDD VDD pfet_03v3 L=0.6u W=3u nf=3
M10 D1 CLK VDD VDD pfet_03v3 L=0.6u W=3u nf=3
M11 D2 CLK VDD VDD pfet_03v3 L=0.6u W=3u nf=3
.ends gpt_luna_strongarm_comparator

.subckt ox_alpha_strongarm_comparator VDD VSS INP INN CLK OUTP OUTN
M1 SN CLK VSS VSS nfet_03v3 L=0.5u W=9.1u nf=1
M2 SN_P INN SN VSS nfet_03v3 L=0.7u W=3u nf=1
M3 SN_N INP SN VSS nfet_03v3 L=0.7u W=3u nf=1
M4 OUTN OUTP SN_N VSS nfet_03v3 L=0.5u W=2.3u nf=1
M5 OUTP OUTN SN_P VSS nfet_03v3 L=0.5u W=2.3u nf=1
M6 OUTN OUTP VDD VDD pfet_03v3 L=0.5u W=3u nf=1
M7 OUTP OUTN VDD VDD pfet_03v3 L=0.5u W=3u nf=1
M8 SN_N CLK VDD VDD pfet_03v3 L=0.5u W=0.8u nf=1
M9 SN_P CLK VDD VDD pfet_03v3 L=0.5u W=0.8u nf=1
M10 OUTN CLK VDD VDD pfet_03v3 L=0.5u W=1.6u nf=1
M11 OUTP CLK VDD VDD pfet_03v3 L=0.5u W=1.6u nf=1
.ends ox_alpha_strongarm_comparator

.subckt deepseek_vref_1v2 VDD VSS VREF IBIAS
M1 IBIAS IBIAS VSS VSS nfet_03v3 L=2u W=4u nf=2
M2 pm IBIAS VSS VSS nfet_03v3 L=2u W=4u nf=2
M3 pm pm VDD VDD pfet_03v3 L=2u W=4u nf=2
M4 VREF pm VDD VDD pfet_03v3 L=2u W=8u nf=2
M5 VREF VREF VSS VSS nfet_03v3 L=0.5u W=1.2u nf=1
.ends deepseek_vref_1v2

.subckt gpt_luna_vref_1v2 VDD VSS VREF IBIAS
M1 IBIAS IBIAS VDD VDD pfet_03v3 L=8u W=2u nf=1
M2 VREF IBIAS VDD VDD pfet_03v3 L=8u W=2u nf=1
M3 VREF VREF VMB VSS nfet_03v3 L=0.28u W=9.5u nf=1
M4 VMB VREF VSS VSS nfet_03v3 L=8u W=9.5u nf=1
.ends gpt_luna_vref_1v2

.subckt ox_alpha_vref_1v2 VDD VSS VREF IBIAS
M1 IBIAS IBIAS VDD VDD pfet_03v3 W=2u L=8u nf=1
M2 VREF IBIAS VDD VDD pfet_03v3 W=2u L=8u nf=1
M3 VREF VREF VMB VSS nfet_03v3 W=9.6u L=0.35u nf=12
M4 VMB VREF VSS VSS nfet_03v3 W=9.5u L=7.45u nf=1
.ends ox_alpha_vref_1v2

* LVS-native representation of spice/claude-opus-5_temp_sensor.spice.
* The GF180 KLayout LVS runset does not emit the MIM timing capacitor into
* its comparison netlist, so this topology mirrors the extracted devices.
.subckt claude_opus_5_temp_sensor VDD VSS TEMP_OUT
M1  NB1 NBP VDD VDD pfet_03v3 L=4u W=4u nf=1
M2  NBP NBP VDD VDD pfet_03v3 L=4u W=4u nf=1
M3  NB1 NB1 VSS VSS nfet_03v3 L=4u W=1u nf=1
M4  NBP NB1 NRS VSS nfet_03v3 L=4u W=4u nf=1
R1  NRS VSS VSS 35000 ppolyf_u L=100u W=1u
M5  NSU VSS VDD VDD pfet_03v3 L=9.5u W=0.6u nf=1
M6  NSU NB1 VSS VSS nfet_03v3 L=0.6u W=4u nf=1
M7  NBP NSU VSS VSS nfet_03v3 L=1u W=1u nf=1
M8  NCAP NBP VDD VDD pfet_03v3 L=4u W=4u nf=1
M9  NCAP TEMP_OUT NSK VSS nfet_03v3 L=0.6u W=4u nf=1
M10 NSK NB1 VSS VSS nfet_03v3 L=4u W=2u nf=1
M11 NPA NCAP VDD VDD pfet_03v3 L=4u W=2u nf=1
M12 NST NCAP NPA VDD pfet_03v3 L=4u W=2u nf=1
M13 VSS NST NPA VDD pfet_03v3 L=4u W=4u nf=1
M14 NNB NCAP VSS VSS nfet_03v3 L=4u W=1u nf=1
M15 NST NCAP NNB VSS nfet_03v3 L=4u W=1u nf=1
M16 VDD NST NNB VSS nfet_03v3 L=4u W=2u nf=1
M17 TEMP_OUT NST VDD VDD pfet_03v3 L=1u W=6u nf=1
M18 TEMP_OUT NST VSS VSS nfet_03v3 L=1u W=3u nf=1
.ends claude_opus_5_temp_sensor

* The current 3p3 GDS pad uses the 40um x 10um pad geometry and four
* parallel diode fingers.  ASIG5V is the internal label present in this GDS.
.subckt io_secondary_3p3 VDD TO_GATE ASIG5V VSS
R1 TO_GATE ASIG5V VDD 87.5 ppolyf_u L=10u W=40u
D2 VSS TO_GATE diode_nd2ps_03v3 area=100p pj=40u m=4
D1 TO_GATE VDD diode_pd2nw_03v3 area=100p pj=40u m=4
.ends io_secondary_3p3

* Topology reconstructed from mbg-d08.gds.  Pin order follows the extracted
* top-level labels: temp_out clk inp inn ibias vdd vss, then nine outputs.
.subckt mbg_d08 temp_out clk inp inn ibias vdd vss
+ deepseek_ota gpt_ota oxa_ota
+ deepseek_cmp gpt_cmp oxa_cmp
+ deepseek_vref gpt_vref oxa_vref

XIO_CLK vdd clk_core clk vss io_secondary_3p3
XIO_INP vdd inp_core inp vss io_secondary_3p3
XIO_INN vdd inn_core inn vss io_secondary_3p3
XIO_IBIAS vdd ibias_core ibias vss io_secondary_3p3
XIO_TEMP vdd temp_out_core temp_out vss io_secondary_3p3

XOTA_DS vdd vss inp_core inn_core deepseek_ota_core ibias_core deepseek_ota
XOTA_GPT vdd vss inp_core inn_core gpt_ota_core ibias_core gpt_luna_ota
XOTA_OXA vdd vss inp_core inn_core oxa_ota_core ibias_core ox_alpha_ota
XCMP_DS vdd vss inp_core inn_core clk_core deepseek_cmp_core deepseek_cmp_n deepseek_strongarm_comparator
XCMP_GPT vdd vss inp_core inn_core clk_core gpt_cmp_core gpt_cmp_n gpt_luna_strongarm_comparator
XCMP_OXA vdd vss inp_core inn_core clk_core oxa_cmp_core oxa_cmp_n ox_alpha_strongarm_comparator
XVREF_DS vdd vss deepseek_vref_core ibias_core deepseek_vref_1v2
XVREF_GPT vdd vss gpt_vref_core ibias_core gpt_luna_vref_1v2
XVREF_OXA vdd vss oxa_vref_core ibias_core ox_alpha_vref_1v2
XTEMP_CLAUDE vdd vss temp_out_core claude_opus_5_temp_sensor

XIO_DS_OTA vdd deepseek_ota_core deepseek_ota vss io_secondary_3p3
XIO_GPT_OTA vdd gpt_ota_core gpt_ota vss io_secondary_3p3
XIO_OXA_OTA vdd oxa_ota_core oxa_ota vss io_secondary_3p3
XIO_DS_CMP vdd deepseek_cmp_core deepseek_cmp vss io_secondary_3p3
XIO_GPT_CMP vdd gpt_cmp_core gpt_cmp vss io_secondary_3p3
XIO_OXA_CMP vdd oxa_cmp_core oxa_cmp vss io_secondary_3p3
XIO_DS_VREF vdd deepseek_vref_core deepseek_vref vss io_secondary_3p3
XIO_GPT_VREF vdd gpt_vref_core gpt_vref vss io_secondary_3p3
XIO_OXA_VREF vdd oxa_vref_core oxa_vref vss io_secondary_3p3
.ends mbg_d08
