* Extracted by KLayout with GF180MCU LVS runset on : 28/08/2026 19:08

.SUBCKT mbg-d08 vdd oxa_vref gpt_vref deepseek_vref oxa_cmp gpt_cmp
+ deepseek_cmp oxa_ota gpt_ota deepseek_ota inp clk inn ibias vss
X$1 \$7 vdd vss temp_sensor
X$2 \$8 vdd \$6 vss vref_1v2$2
X$3 \$16 vdd \$6 vss vref_1v2$1
X$4 \$6 \$30 vdd vss vref_1v2
X$5 \$4 \$5 \$44 vdd \$3 vss strongarm_comparator$2
X$6 \$3 \$5 \$4 \$61 vdd vss strongarm_comparator$3
X$7 \$3 \$5 \$4 \$78 vdd vss strongarm_comparator
X$8 \$6 \$4 \$5 \$93 vdd vss ota$2
X$9 \$6 \$5 \$4 \$128 vdd vss ota$1
X$10 \$6 \$5 \$4 \$127 vdd vss ota
X$22 ibias \$6 vdd vss io_secondary_3p3
X$23 inn \$4 vdd vss io_secondary_3p3
X$24 inp \$5 vdd vss io_secondary_3p3
X$25 gpt_ota \$128 vdd vss io_secondary_3p3
X$26 deepseek_ota \$127 vdd vss io_secondary_3p3
X$27 oxa_vref \$8 vdd vss io_secondary_3p3
X$28 oxa_cmp \$44 vdd vss io_secondary_3p3
X$29 deepseek_vref \$30 vdd vss io_secondary_3p3
X$30 gpt_vref \$16 vdd vss io_secondary_3p3
X$31 deepseek_cmp \$78 vdd vss io_secondary_3p3
X$32 oxa_ota \$93 vdd vss io_secondary_3p3
X$33 \$I125 \$7 vdd vss io_secondary_3p3
X$34 gpt_cmp \$61 vdd vss io_secondary_3p3
X$36 clk \$3 vdd vss io_secondary_3p3
.ENDS mbg-d08

.SUBCKT temp_sensor TEMP_OUT VDD VSS
M$1 \$1946 \$1948 VDD VDD pfet_03v3 L=4U W=4U AS=2.4P AD=2.4P PS=9.2U PD=9.2U
M$2 \$1944 \$4 \$1964 VDD pfet_03v3 L=4U W=2U AS=1.2P AD=1.2P PS=5.2U PD=5.2U
M$3 \$1943 VSS VDD VDD pfet_03v3 L=9.5U W=0.6U AS=0.36P AD=0.36P PS=2.4U PD=2.4U
M$4 \$1948 \$1948 VDD VDD pfet_03v3 L=4U W=4U AS=2.4P AD=2.4P PS=9.2U PD=9.2U
M$5 VSS \$1944 \$1964 VDD pfet_03v3 L=4U W=4U AS=2.4P AD=2.4P PS=9.2U PD=9.2U
M$6 TEMP_OUT \$1944 VDD VDD pfet_03v3 L=1U W=6U AS=3.6P AD=3.6P PS=13.2U
+ PD=13.2U
M$7 \$4 \$1948 VDD VDD pfet_03v3 L=4U W=4U AS=2.4P AD=2.4P PS=9.2U PD=9.2U
M$8 \$1964 \$4 VDD VDD pfet_03v3 L=4U W=2U AS=1.2P AD=1.2P PS=5.2U PD=5.2U
M$9 \$1946 \$1946 VSS VSS nfet_03v3 L=4U W=1U AS=0.6P AD=0.6P PS=3.2U PD=3.2U
M$10 VDD \$1944 \$1950 VSS nfet_03v3 L=4U W=2U AS=1.2P AD=1.2P PS=5.2U PD=5.2U
M$11 \$1944 \$4 \$1950 VSS nfet_03v3 L=4U W=1U AS=0.6P AD=0.6P PS=3.2U PD=3.2U
M$12 TEMP_OUT \$1944 VSS VSS nfet_03v3 L=1U W=3U AS=1.8P AD=1.8P PS=7.2U PD=7.2U
M$13 \$1949 \$1946 VSS VSS nfet_03v3 L=4U W=2U AS=1.2P AD=1.2P PS=5.2U PD=5.2U
M$14 \$1948 \$1946 \$1947 VSS nfet_03v3 L=4U W=4U AS=2.4P AD=2.4P PS=9.2U
+ PD=9.2U
M$15 \$1950 \$4 VSS VSS nfet_03v3 L=4U W=1U AS=0.6P AD=0.6P PS=3.2U PD=3.2U
M$16 \$1948 \$1943 VSS VSS nfet_03v3 L=1U W=1U AS=0.6P AD=0.6P PS=3.2U PD=3.2U
M$17 \$4 TEMP_OUT \$1949 VSS nfet_03v3 L=0.6U W=4U AS=2.4P AD=2.4P PS=9.2U
+ PD=9.2U
M$18 \$1943 \$1946 VSS VSS nfet_03v3 L=0.6U W=4U AS=2.4P AD=2.4P PS=9.2U PD=9.2U
R$19 VSS \$1947 VSS 35000 ppolyf_u L=100U W=1U
.ENDS temp_sensor

.SUBCKT vref_1v2$1 VREF VDD IBIAS VSS
M$1 VREF IBIAS VDD VDD pfet_03v3 L=8U W=2U AS=1.2P AD=1.2P PS=5.2U PD=5.2U
M$2 IBIAS IBIAS VDD VDD pfet_03v3 L=8U W=2U AS=1.2P AD=1.2P PS=5.2U PD=5.2U
M$3 \$4 VREF VSS VSS nfet_03v3 L=8U W=9.5U AS=5.7P AD=5.7P PS=20.2U PD=20.2U
M$4 VREF VREF \$4 VSS nfet_03v3 L=0.28U W=9.5U AS=7.125P AD=7.125P PS=20.5U
+ PD=20.5U
.ENDS vref_1v2$1

.SUBCKT vref_1v2 IBIAS VREF VDD VSS
M$1 VREF \$7 VDD VDD pfet_03v3 L=2U W=8U AS=3.52P AD=3.52P PS=13.76U PD=13.76U
M$3 \$7 \$7 VDD VDD pfet_03v3 L=2U W=4U AS=1.76P AD=1.76P PS=7.76U PD=7.76U
M$5 IBIAS IBIAS VSS VSS nfet_03v3 L=2U W=4U AS=1.76P AD=1.76P PS=7.76U PD=7.76U
M$7 \$7 IBIAS VSS VSS nfet_03v3 L=2U W=4U AS=1.76P AD=1.76P PS=7.76U PD=7.76U
M$9 VREF VREF VSS VSS nfet_03v3 L=0.5U W=1.2U AS=0.72P AD=0.72P PS=3.6U PD=3.6U
.ENDS vref_1v2

.SUBCKT strongarm_comparator$2 INN INP OUTP VDD CLK VSS
M$1 OUTN OUTP VDD VDD pfet_03v3 L=0.5U W=3U AS=1.8P AD=1.8P PS=7.2U PD=7.2U
M$2 OUTP OUTN VDD VDD pfet_03v3 L=0.5U W=3U AS=1.8P AD=1.8P PS=7.2U PD=7.2U
M$3 OUTP CLK VDD VDD pfet_03v3 L=0.5U W=1.6U AS=0.96P AD=0.96P PS=4.4U PD=4.4U
M$4 OUTN CLK VDD VDD pfet_03v3 L=0.5U W=1.6U AS=0.96P AD=0.96P PS=4.4U PD=4.4U
M$5 \$10 CLK VDD VDD pfet_03v3 L=0.5U W=0.8U AS=0.48P AD=0.48P PS=2.8U PD=2.8U
M$6 \$9 CLK VDD VDD pfet_03v3 L=0.5U W=0.8U AS=0.48P AD=0.48P PS=2.8U PD=2.8U
M$7 \$10 INN \$4 VSS nfet_03v3 L=0.7U W=3U AS=1.8P AD=1.8P PS=7.2U PD=7.2U
M$8 OUTP OUTN \$10 VSS nfet_03v3 L=0.5U W=2.3U AS=1.38P AD=1.38P PS=5.8U PD=5.8U
M$9 OUTN OUTP \$9 VSS nfet_03v3 L=0.5U W=2.3U AS=1.38P AD=1.38P PS=5.8U PD=5.8U
M$10 \$9 INP \$4 VSS nfet_03v3 L=0.7U W=3U AS=1.8P AD=1.8P PS=7.2U PD=7.2U
M$11 \$4 CLK VSS VSS nfet_03v3 L=0.5U W=9.1U AS=5.46P AD=5.46P PS=19.4U PD=19.4U
.ENDS strongarm_comparator$2

.SUBCKT vref_1v2$2 VREF VDD IBIAS VSS
M$1 VREF IBIAS VDD VDD pfet_03v3 L=8U W=2U AS=1.2P AD=1.2P PS=5.2U PD=5.2U
M$2 IBIAS IBIAS VDD VDD pfet_03v3 L=8U W=2U AS=1.2P AD=1.2P PS=5.2U PD=5.2U
M$3 VREF VREF \$5 VSS nfet_03v3 L=0.35U W=9.6U AS=2.944P AD=2.944P PS=17.76U
+ PD=17.76U
M$15 \$5 VREF VSS VSS nfet_03v3 L=7.45U W=9.5U AS=5.7P AD=5.7P PS=20.2U PD=20.2U
.ENDS vref_1v2$2

.SUBCKT strongarm_comparator$3 CLK INP INN OUTP VDD VSS
M$1 \$10 CLK VDD VDD pfet_03v3 L=0.6U W=3U AS=1.16P AD=1.16P PS=6.32U PD=6.32U
M$4 OUTN OUTP VDD VDD pfet_03v3 L=0.6U W=3U AS=1.16P AD=1.16P PS=6.32U PD=6.32U
M$7 OUTP CLK VDD VDD pfet_03v3 L=0.6U W=3U AS=1.16P AD=1.16P PS=6.32U PD=6.32U
M$10 \$11 CLK VDD VDD pfet_03v3 L=0.6U W=3U AS=1.16P AD=1.16P PS=6.32U PD=6.32U
M$13 OUTN CLK VDD VDD pfet_03v3 L=0.6U W=3U AS=1.16P AD=1.16P PS=6.32U PD=6.32U
M$16 OUTP OUTN VDD VDD pfet_03v3 L=0.6U W=3U AS=1.16P AD=1.16P PS=6.32U PD=6.32U
M$19 OUTN OUTP \$10 VSS nfet_03v3 L=0.6U W=5U AS=1.72P AD=1.72P PS=9.44U
+ PD=9.44U
M$24 OUTP OUTN \$11 VSS nfet_03v3 L=0.6U W=5U AS=1.72P AD=1.72P PS=9.44U
+ PD=9.44U
M$29 \$11 INN \$9 VSS nfet_03v3 L=0.6U W=3U AS=1.16P AD=1.16P PS=6.32U PD=6.32U
M$32 \$9 CLK VSS VSS nfet_03v3 L=0.6U W=4U AS=1.44P AD=1.44P PS=7.88U PD=7.88U
M$36 \$10 INP \$9 VSS nfet_03v3 L=0.6U W=3U AS=1.16P AD=1.16P PS=6.32U PD=6.32U
.ENDS strongarm_comparator$3

.SUBCKT ota IBIAS INP INN OUT VDD VSS
M$1 OUT \$10 VDD VDD pfet_03v3 L=1U W=2.4U AS=0.864P AD=0.864P PS=5.88U PD=5.88U
M$5 \$10 \$10 VDD VDD pfet_03v3 L=1U W=2.4U AS=0.864P AD=0.864P PS=5.88U
+ PD=5.88U
M$9 IBIAS IBIAS VSS VSS nfet_03v3 L=1U W=4U AS=1.44P AD=1.44P PS=7.88U PD=7.88U
M$13 \$5 IBIAS VSS VSS nfet_03v3 L=1U W=8U AS=2.88P AD=2.88P PS=12.88U PD=12.88U
M$17 \$10 INP \$5 VSS nfet_03v3 L=1U W=4U AS=1.44P AD=1.44P PS=7.88U PD=7.88U
M$21 OUT INN \$5 VSS nfet_03v3 L=1U W=4U AS=1.44P AD=1.44P PS=7.88U PD=7.88U
.ENDS ota

.SUBCKT strongarm_comparator CLK INP INN OUTP VDD VSS
M$1 \$9 CLK VDD VDD pfet_03v3 L=0.5U W=2U AS=1.2P AD=1.2P PS=5.2U PD=5.2U
M$2 \$10 CLK VDD VDD pfet_03v3 L=0.5U W=2U AS=1.2P AD=1.2P PS=5.2U PD=5.2U
M$3 OUTP CLK VDD VDD pfet_03v3 L=0.5U W=2U AS=1.2P AD=1.2P PS=5.2U PD=5.2U
M$4 OUTN OUTP VDD VDD pfet_03v3 L=0.5U W=6U AS=2.32P AD=2.32P PS=10.32U
+ PD=10.32U
M$7 OUTP OUTN VDD VDD pfet_03v3 L=0.5U W=6U AS=2.32P AD=2.32P PS=10.32U
+ PD=10.32U
M$10 OUTN CLK VDD VDD pfet_03v3 L=0.5U W=2U AS=1.2P AD=1.2P PS=5.2U PD=5.2U
M$11 OUTN OUTP \$9 VSS nfet_03v3 L=0.5U W=6U AS=2.32P AD=2.32P PS=10.32U
+ PD=10.32U
M$14 \$10 INN \$8 VSS nfet_03v3 L=0.6U W=16U AS=5.12P AD=5.12P PS=23.12U
+ PD=23.12U
M$22 \$8 CLK VSS VSS nfet_03v3 L=0.5U W=2U AS=1.2P AD=1.2P PS=5.2U PD=5.2U
M$23 \$9 INP \$8 VSS nfet_03v3 L=0.6U W=16U AS=5.12P AD=5.12P PS=23.12U
+ PD=23.12U
M$31 OUTP OUTN \$10 VSS nfet_03v3 L=0.5U W=6U AS=2.32P AD=2.32P PS=10.32U
+ PD=10.32U
.ENDS strongarm_comparator

.SUBCKT ota$2 IBIAS INN INP OUT VDD VSS
M$1 OUT \$10 VDD VDD pfet_03v3 L=4U W=30U AS=10.8P AD=10.8P PS=40.38U PD=40.38U
M$5 \$10 \$10 VDD VDD pfet_03v3 L=4U W=30U AS=10.8P AD=10.8P PS=40.38U PD=40.38U
M$9 \$10 INN \$5 VSS nfet_03v3 L=2U W=6U AS=3.6P AD=3.6P PS=13.2U PD=13.2U
M$10 \$5 IBIAS VSS VSS nfet_03v3 L=4U W=12U AS=5.28P AD=5.28P PS=19.76U
+ PD=19.76U
M$12 OUT INP \$5 VSS nfet_03v3 L=2U W=6U AS=3.6P AD=3.6P PS=13.2U PD=13.2U
M$13 IBIAS IBIAS VSS VSS nfet_03v3 L=2U W=2U AS=1.2P AD=1.2P PS=5.2U PD=5.2U
.ENDS ota$2

.SUBCKT ota$1 IBIAS INP INN OUT VDD VSS
M$1 OUT \$10 VDD VDD pfet_03v3 L=0.8U W=6U AS=2.16P AD=2.16P PS=10.38U PD=10.38U
M$5 \$10 \$10 VDD VDD pfet_03v3 L=0.8U W=6U AS=2.16P AD=2.16P PS=10.38U
+ PD=10.38U
M$9 \$5 IBIAS VSS VSS nfet_03v3 L=1U W=4U AS=1.44P AD=1.44P PS=7.88U PD=7.88U
M$13 IBIAS IBIAS VSS VSS nfet_03v3 L=1U W=4U AS=1.44P AD=1.44P PS=7.88U PD=7.88U
M$17 \$10 INP \$5 VSS nfet_03v3 L=0.6U W=4U AS=1.44P AD=1.44P PS=7.88U PD=7.88U
M$21 OUT INN \$5 VSS nfet_03v3 L=0.6U W=4U AS=1.44P AD=1.44P PS=7.88U PD=7.88U
.ENDS ota$1

.SUBCKT io_secondary_3p3 to_gate ASIG5V VDD VSS
R$1 to_gate ASIG5V VDD 87.5 ppolyf_u L=10U W=40U
D$2 to_gate VDD diode_pd2nw_03v3 A=400P P=160U
D$6 VSS to_gate diode_nd2ps_03v3 A=400P P=160U
.ENDS io_secondary_3p3
