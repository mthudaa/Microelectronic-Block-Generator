* Extended post-layout top-level simulation using Magic-extracted parasitics.
.include "/foss/pdks/ciel/gf180mcu/versions/7b70722e33c03fcb5dabcf4d479fb0822d9251c9/gf180mcuD/libs.tech/ngspice/design.ngspice"
.lib "/foss/pdks/ciel/gf180mcu/versions/7b70722e33c03fcb5dabcf4d479fb0822d9251c9/gf180mcuD/libs.tech/ngspice/sm141064.ngspice" typical
.lib "/foss/pdks/ciel/gf180mcu/versions/7b70722e33c03fcb5dabcf4d479fb0822d9251c9/gf180mcuD/libs.tech/ngspice/sm141064.ngspice" diode_typical
.lib "/foss/pdks/ciel/gf180mcu/versions/7b70722e33c03fcb5dabcf4d479fb0822d9251c9/gf180mcuD/libs.tech/ngspice/sm141064.ngspice" res_typical
.lib "/foss/pdks/ciel/gf180mcu/versions/7b70722e33c03fcb5dabcf4d479fb0822d9251c9/gf180mcuD/libs.tech/ngspice/sm141064.ngspice" mimcap_typical
.include "post_sim/mbg-d08.pex.spice"
.options rshunt=1e12
.temp 27

VDD_SRC vdd 0 3.3
VSS_SRC vss 0 0
VCLK clk 0 PULSE(0 3.3 20n 0.1n 0.1n 5u 10u)
* Complementary linear ramp: INP offset -200 mV to +200 mV; INN offset +200 mV to -200 mV.
* The 1.65 V common-mode level gives actual pin ramps of 1.45 V to 1.85 V and 1.85 V to 1.45 V over 100 us.
VINP inp 0 PWL(0 0 100u 3.3)
VINN inn 0 PWL(0 3.3 100u 0)
I_BIAS 0 ibias DC 20u

* External loads, matching the pre-layout observation points.
RLOAD_DS_OTA deepseek_ota 0 1G
RLOAD_GPT_OTA gpt_ota 0 1G
RLOAD_OXA_OTA oxa_ota 0 1G
RLOAD_DS_CMP deepseek_cmp 0 1G
RLOAD_GPT_CMP gpt_cmp 0 1G
RLOAD_OXA_CMP oxa_cmp 0 1G
RLOAD_DS_VREF deepseek_vref 0 1G
RLOAD_GPT_VREF gpt_vref 0 1G
RLOAD_OXA_VREF oxa_vref 0 1G
RLOAD_TEMP temp_out 0 1G
CLOAD_DS_OTA deepseek_ota 0 1p
CLOAD_GPT_OTA gpt_ota 0 1p
CLOAD_OXA_OTA oxa_ota 0 1p
CLOAD_DS_CMP deepseek_cmp 0 20f
CLOAD_GPT_CMP gpt_cmp 0 20f
CLOAD_OXA_CMP oxa_cmp 0 20f
CLOAD_DS_VREF deepseek_vref 0 1p
CLOAD_GPT_VREF gpt_vref 0 1p
CLOAD_OXA_VREF oxa_vref 0 1p
CLOAD_TEMP temp_out 0 20f

* Magic PEX pin order: temp_out clk inp inn ibias vdd vss, then outputs.
XDUT clk inp inn ibias vdd vss deepseek_ota gpt_ota oxa_ota deepseek_cmp gpt_cmp oxa_cmp deepseek_vref gpt_vref oxa_vref temp_out mbg_d08_post

.control
set noaskquit
op
print v(deepseek_ota) v(gpt_ota) v(oxa_ota)
print v(deepseek_cmp) v(gpt_cmp) v(oxa_cmp)
print v(deepseek_vref) v(gpt_vref) v(oxa_vref)
print v(temp_out)
tran 1n 100u
let vdiff = v(inp)-v(inn)
wrdata mbg-d08_post_temp_100u_tr.dat v(deepseek_ota) v(gpt_ota) v(oxa_ota) v(deepseek_cmp) v(gpt_cmp) v(oxa_cmp) v(deepseek_vref) v(gpt_vref) v(oxa_vref) v(temp_out) vdiff
.endc
.end
