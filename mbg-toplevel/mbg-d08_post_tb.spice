* Extended post-layout top-level simulation using Magic-extracted parasitics (capacitance only, scale off) of mbg_d08.
.include "/foss/pdks/ciel/gf180mcu/versions/7b70722e33c03fcb5dabcf4d479fb0822d9251c9/gf180mcuD/libs.tech/ngspice/design.ngspice"
.lib "/foss/pdks/ciel/gf180mcu/versions/7b70722e33c03fcb5dabcf4d479fb0822d9251c9/gf180mcuD/libs.tech/ngspice/sm141064.ngspice" typical
.lib "/foss/pdks/ciel/gf180mcu/versions/7b70722e33c03fcb5dabcf4d479fb0822d9251c9/gf180mcuD/libs.tech/ngspice/sm141064.ngspice" diode_typical
.lib "/foss/pdks/ciel/gf180mcu/versions/7b70722e33c03fcb5dabcf4d479fb0822d9251c9/gf180mcuD/libs.tech/ngspice/sm141064.ngspice" res_typical
.lib "/foss/pdks/ciel/gf180mcu/versions/7b70722e33c03fcb5dabcf4d479fb0822d9251c9/gf180mcuD/libs.tech/ngspice/sm141064.ngspice" mimcap_typical
.include "post_sim/mbg-d08.pex.spice"
.options rshunt=1e12
.temp 27

VDD_SRC vdd 0 3.3
VSS_SRC vss 0 0
VCLK clk 0 PULSE(0 3.3 20n 0.1n 0.1n 5u 10u)
* Complementary linear ramp: INP offset -200 mV to +200 mV; INN offset +200 mV to -200 mV.
* The 1.65 V common-mode level gives actual pin ramps of 1.45 V to 1.85 V and 1.85 V to 1.45 V over 100 us.
VINP inp 0 PWL(0 1.450 100u 1.850)
VINN inn 0 PWL(0 1.850 100u 1.450)
I_BIAS 0 ibias DC 20u
* NEURO1B (Opus 5.5) input: 2 uA current step into temp_out at 1 us (same stimulus as its standalone bench);
* its spikes appear on temp_out itself.
I_NEURO 0 temp_out PWL(0 0 1u 0 1.01u 2u)

* External loads: 1 GOhm and the pad capacitance seen by the harness (vref 1 pF, OTA 1 pF here, comparator 20 fF).
RLOAD_GEMINI4ARGON_OTA deepseek_ota 0 1G
RLOAD_GPT62SOL_OTA gpt_ota 0 1G
RLOAD_OPUS55_OTA oxa_ota 0 1G
RLOAD_GEMINI4ARGON_CMP deepseek_cmp 0 1G
RLOAD_GPT62SOL_CMP gpt_cmp 0 1G
RLOAD_OPUS55_CMP oxa_cmp 0 1G
RLOAD_GEMINI4ARGON_VREF deepseek_vref 0 1G
RLOAD_GPT62SOL_VREF gpt_vref 0 1G
RLOAD_OPUS55_VREF oxa_vref 0 1G
RLOAD_TEMP_OUT temp_out 0 1G
CLOAD_GEMINI4ARGON_OTA deepseek_ota 0 1p
CLOAD_GPT62SOL_OTA gpt_ota 0 1p
CLOAD_OPUS55_OTA oxa_ota 0 1p
CLOAD_GEMINI4ARGON_CMP deepseek_cmp 0 20f
CLOAD_GPT62SOL_CMP gpt_cmp 0 20f
CLOAD_OPUS55_CMP oxa_cmp 0 20f
CLOAD_GEMINI4ARGON_VREF deepseek_vref 0 1p
CLOAD_GPT62SOL_VREF gpt_vref 0 1p
CLOAD_OPUS55_VREF oxa_vref 0 1p
CLOAD_TEMP_OUT temp_out 0 20f

* Port order taken from the .subckt line of the included netlist.
XDUT clk inn inp gpt_ota deepseek_ota vss vdd ibias deepseek_cmp oxa_ota gpt_vref deepseek_vref oxa_cmp gpt_cmp oxa_vref temp_out mbg_d08

.control
set noaskquit
op
print v(deepseek_ota) v(gpt_ota) v(oxa_ota)
print v(deepseek_cmp) v(gpt_cmp) v(oxa_cmp)
print v(deepseek_vref) v(gpt_vref) v(oxa_vref)
print v(temp_out)
tran 1n 100u
let vdiff = v(inp)-v(inn)
wrdata mbg-d08_post_tr.dat v(deepseek_ota) v(gpt_ota) v(oxa_ota) v(deepseek_cmp) v(gpt_cmp) v(oxa_cmp) v(deepseek_vref) v(gpt_vref) v(oxa_vref) v(temp_out) vdiff
.endc
.end
