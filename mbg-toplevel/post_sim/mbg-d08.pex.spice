* NGSPICE file created from mbg_d08_post.ext - technology: gf180mcuD

.subckt mbg_d08_post temp_out clk inp inn ibias vdd vss deepseek_ota gpt_ota oxa_ota
+ deepseek_cmp gpt_cmp oxa_cmp deepseek_vref gpt_vref oxa_vref
X0 a_449030_395380# strongarm_comparator$2_0.CLK vdd vdd pfet_03v3 ad=0.48p pd=2.8u as=0.48p ps=2.8u w=0.8u l=0.5u
X1 ota$2_0.OUT a_446966_452332# vdd vdd pfet_03v3 ad=2.1p pd=8.06u as=2.1p ps=8.06u w=7.5u l=4u
X2 strongarm_comparator_0.OUTN io_secondary_3p3_8.ASIG5V a_446992_431778# vss nfet_03v3 ad=1.2p pd=5.2u as=0.56p ps=2.56u w=2u l=0.5u
X3 io_secondary_3p3_4.ASIG5V io_secondary_3p3_4.ASIG5V a_450261_333180# vss nfet_03v3 ad=0.224p pd=1.36u as=0.224p ps=1.36u w=0.8u l=0.35u
X4 a_454802_322196# a_451058_322196# vdd vdd pfet_03v3 ad=1.2p pd=5.2u as=1.2p ps=5.2u w=2u l=4u
X5 vdd a_449526_465503# a_449526_465503# vdd pfet_03v3 ad=0.9p pd=4.2u as=0.42p ps=2.06u w=1.5u l=0.8u
X6 io_secondary_3p3_8.ASIG5V strongarm_comparator_0.OUTN vdd vdd pfet_03v3 ad=1.2p pd=5.2u as=0.56p ps=2.56u w=2u l=0.5u
X7 a_450261_333180# io_secondary_3p3_4.ASIG5V vss vss nfet_03v3 ad=5.7p pd=20.2u as=5.7p ps=20.2u w=9.5u l=7.45u
X8 io_secondary_3p3_2.ASIG5V io_secondary_3p3_2.ASIG5V vss vss nfet_03v3 ad=0.72p pd=3.6u as=0.72p ps=3.6u w=1.2u l=0.5u
D0 vss oxa_vref diode_nd2ps_03v3 pj=40p area=99.99999p
D1 vss deepseek_vref diode_nd2ps_03v3 pj=40p area=99.99999p
X9 a_449030_395380# strongarm_comparator$2_0.INN a_449020_392562# vss nfet_03v3 ad=1.8p pd=7.2u as=1.8p ps=7.2u w=3u l=0.7u
X10 a_449366_474266# strongarm_comparator$2_0.INP a_449296_472055# vss nfet_03v3 ad=0.28p pd=1.56u as=0.6p ps=3.2u w=1u l=1u
X11 vref_1v2$2_0.IBIAS vref_1v2$2_0.IBIAS vss vss nfet_03v3 ad=0.28p pd=1.56u as=0.6p ps=3.2u w=1u l=1u
D2 oxa_cmp vdd diode_pd2nw_03v3 pj=40p area=99.99999p
X12 a_449366_474266# a_449366_474266# vdd vdd pfet_03v3 ad=0.168p pd=1.16u as=0.36p ps=2.4u w=0.6u l=1u
X13 a_449616_457872# strongarm_comparator$2_0.INN io_secondary_3p3_10.ASIG5V vss nfet_03v3 ad=0.28p pd=1.56u as=0.28p ps=1.56u w=1u l=0.6u
X14 a_446108_415153# strongarm_comparator$2_0.INP a_447160_411233# vss nfet_03v3 ad=0.6p pd=3.2u as=0.28p ps=1.56u w=1u l=0.6u
X15 io_secondary_3p3_4.ASIG5V oxa_vref vdd ppolyf_u r_width=40u r_length=10u
X16 ota$2_0.OUT oxa_ota vdd ppolyf_u r_width=40u r_length=10u
X17 a_450384_431778# strongarm_comparator$2_0.INN a_448488_431778# vss nfet_03v3 ad=0.56p pd=2.56u as=0.56p ps=2.56u w=2u l=0.6u
X18 a_449616_457872# strongarm_comparator$2_0.INP a_449526_465503# vss nfet_03v3 ad=0.6p pd=3.2u as=0.28p ps=1.56u w=1u l=0.6u
D3 vss oxa_ota diode_nd2ps_03v3 pj=40p area=99.99999p
X19 a_447160_411233# strongarm_comparator$2_0.CLK vss vss nfet_03v3 ad=0.28p pd=1.56u as=0.28p ps=1.56u w=1u l=0.6u
D4 vss gpt_cmp diode_nd2ps_03v3 pj=40p area=99.99999p
D5 vss deepseek_ota diode_nd2ps_03v3 pj=40p area=99.99999p
X20 a_444522_318971# a_446514_321988# vdd vdd pfet_03v3 ad=2.4p pd=9.2u as=2.4p ps=9.2u w=4u l=4u
D6 gpt_vref vdd diode_pd2nw_03v3 pj=40p area=99.99999p
D7 gpt_ota vdd diode_pd2nw_03v3 pj=40p area=99.99999p
D8 deepseek_cmp vdd diode_pd2nw_03v3 pj=40p area=99.99999p
X21 vss vref_1v2$2_0.IBIAS vref_1v2$2_0.IBIAS vss nfet_03v3 ad=1.2p pd=5.2u as=0.56p ps=2.56u w=2u l=2u
X22 a_449366_474266# a_449366_474266# vdd vdd pfet_03v3 ad=0.168p pd=1.16u as=0.168p ps=1.16u w=0.6u l=1u
X23 a_449616_457872# strongarm_comparator$2_0.INN io_secondary_3p3_10.ASIG5V vss nfet_03v3 ad=0.6p pd=3.2u as=0.28p ps=1.56u w=1u l=0.6u
X24 vref_1v2$1_0.VREF vref_1v2$1_0.VREF a_449574_352580# vss nfet_03v3 ad=7.125p pd=20.5u as=7.125p ps=20.5u w=9.5u l=0.28u
X25 a_449366_474266# strongarm_comparator$2_0.INP a_449296_472055# vss nfet_03v3 ad=0.28p pd=1.56u as=0.28p ps=1.56u w=1u l=1u
D9 vss deepseek_vref diode_nd2ps_03v3 pj=40p area=99.99999p
X26 inn strongarm_comparator$2_0.INN vdd ppolyf_u r_width=40u r_length=10u
X27 strongarm_comparator$3_0.OUTN strongarm_comparator$3_0.OUTP a_446108_415153# vss nfet_03v3 ad=0.6p pd=3.2u as=0.28p ps=1.56u w=1u l=0.6u
X28 vdd a_449366_474266# ota_0.OUT vdd pfet_03v3 ad=0.36p pd=2.4u as=0.168p ps=1.16u w=0.6u l=1u
X29 vdd a_449526_465503# io_secondary_3p3_10.ASIG5V vdd pfet_03v3 ad=0.42p pd=2.06u as=0.42p ps=2.06u w=1.5u l=0.8u
D10 temp_out vdd diode_pd2nw_03v3 pj=40p area=99.99999p
D11 oxa_cmp vdd diode_pd2nw_03v3 pj=40p area=99.99999p
X30 vss vref_1v2$2_0.IBIAS vref_1v2$2_0.IBIAS vss nfet_03v3 ad=0.28p pd=1.56u as=0.28p ps=1.56u w=1u l=1u
X31 a_450261_333180# io_secondary_3p3_4.ASIG5V io_secondary_3p3_4.ASIG5V vss nfet_03v3 ad=0.48p pd=2.8u as=0.224p ps=1.36u w=0.8u l=0.35u
X32 a_448488_431778# strongarm_comparator$2_0.INN a_450384_431778# vss nfet_03v3 ad=0.56p pd=2.56u as=0.56p ps=2.56u w=2u l=0.6u
X33 a_447764_415153# strongarm_comparator$3_0.OUTN strongarm_comparator$3_0.OUTP vss nfet_03v3 ad=0.28p pd=1.56u as=0.28p ps=1.56u w=1u l=0.6u
X34 clk strongarm_comparator$2_0.CLK vdd ppolyf_u r_width=40u r_length=10u
X35 a_450384_431778# strongarm_comparator$2_0.INP a_446992_431778# vss nfet_03v3 ad=0.56p pd=2.56u as=0.56p ps=2.56u w=2u l=0.6u
X36 a_450384_431778# strongarm_comparator$2_0.CLK vss vss nfet_03v3 ad=1.2p pd=5.2u as=1.2p ps=5.2u w=2u l=0.5u
X37 vss strongarm_comparator$2_0.CLK a_447160_411233# vss nfet_03v3 ad=0.6p pd=3.2u as=0.28p ps=1.56u w=1u l=0.6u
D12 vss deepseek_ota diode_nd2ps_03v3 pj=40p area=99.99999p
D13 ibias vdd diode_pd2nw_03v3 pj=40p area=99.99999p
X38 vref_1v2$2_0.IBIAS vref_1v2$2_0.IBIAS vss vss nfet_03v3 ad=0.28p pd=1.56u as=0.28p ps=1.56u w=1u l=1u
D14 inn vdd diode_pd2nw_03v3 pj=40p area=99.99999p
X39 vss vref_1v2$2_0.IBIAS a_450032_449122# vss nfet_03v3 ad=3.6p pd=13.2u as=1.68p ps=6.56u w=6u l=4u
D15 vss inp diode_nd2ps_03v3 pj=40p area=99.99999p
X40 a_450032_449122# vref_1v2$2_0.IBIAS vss vss nfet_03v3 ad=1.68p pd=6.56u as=3.6p ps=13.2u w=6u l=4u
X41 a_450384_431778# strongarm_comparator$2_0.INP a_446992_431778# vss nfet_03v3 ad=0.56p pd=2.56u as=0.56p ps=2.56u w=2u l=0.6u
X42 io_secondary_3p3_3.ASIG5V strongarm_comparator$2_0.OUTN vdd vdd pfet_03v3 ad=1.8p pd=7.2u as=1.8p ps=7.2u w=3u l=0.5u
X43 a_451058_322196# vss cap_mim_2f0_m4m5_noshield c_width=34u c_length=34u
X44 vdd a_449526_465503# a_449526_465503# vdd pfet_03v3 ad=0.42p pd=2.06u as=0.42p ps=2.06u w=1.5u l=0.8u
D16 inp vdd diode_pd2nw_03v3 pj=40p area=99.99999p
X45 a_446108_415153# strongarm_comparator$3_0.OUTP strongarm_comparator$3_0.OUTN vss nfet_03v3 ad=0.28p pd=1.56u as=0.28p ps=1.56u w=1u l=0.6u
X46 io_secondary_3p3_4.ASIG5V io_secondary_3p3_4.ASIG5V a_450261_333180# vss nfet_03v3 ad=0.224p pd=1.36u as=0.48p ps=2.8u w=0.8u l=0.35u
X47 vref_1v2$1_0.VREF gpt_vref vdd ppolyf_u r_width=40u r_length=10u
X48 ota$2_0.OUT strongarm_comparator$2_0.INP a_450032_449122# vss nfet_03v3 ad=3.6p pd=13.2u as=3.6p ps=13.2u w=6u l=2u
X49 strongarm_comparator$3_0.OUTP strongarm_comparator$2_0.CLK vdd vdd pfet_03v3 ad=0.28p pd=1.56u as=0.6p ps=3.2u w=1u l=0.6u
D17 clk vdd diode_pd2nw_03v3 pj=40p area=99.99999p
D18 vss inn diode_nd2ps_03v3 pj=40p area=99.99999p
D19 vss temp_out diode_nd2ps_03v3 pj=40p area=99.99999p
X50 a_451058_322196# a_446514_321988# vdd vdd pfet_03v3 ad=2.4p pd=9.2u as=2.4p ps=9.2u w=4u l=4u
D20 vss gpt_vref diode_nd2ps_03v3 pj=40p area=99.99999p
D21 vss gpt_ota diode_nd2ps_03v3 pj=40p area=99.99999p
X51 a_449526_465503# strongarm_comparator$2_0.INP a_449616_457872# vss nfet_03v3 ad=0.28p pd=1.56u as=0.6p ps=3.2u w=1u l=0.6u
X52 a_446966_452332# a_446966_452332# vdd vdd pfet_03v3 ad=2.1p pd=8.06u as=2.1p ps=8.06u w=7.5u l=4u
X53 strongarm_comparator_0.OUTN io_secondary_3p3_8.ASIG5V a_446992_431778# vss nfet_03v3 ad=0.56p pd=2.56u as=1.2p ps=5.2u w=2u l=0.5u
D22 vss deepseek_cmp diode_nd2ps_03v3 pj=40p area=99.99999p
X54 a_447858_395380# strongarm_comparator$2_0.INP a_449020_392562# vss nfet_03v3 ad=1.8p pd=7.2u as=1.8p ps=7.2u w=3u l=0.7u
D23 vss oxa_cmp diode_nd2ps_03v3 pj=40p area=99.99999p
D24 ibias vdd diode_pd2nw_03v3 pj=40p area=99.99999p
X55 a_449296_472055# strongarm_comparator$2_0.INN ota_0.OUT vss nfet_03v3 ad=0.6p pd=3.2u as=0.28p ps=1.56u w=1u l=1u
X56 vdd a_446966_452332# a_446966_452332# vdd pfet_03v3 ad=2.1p pd=8.06u as=2.1p ps=8.06u w=7.5u l=4u
D25 oxa_vref vdd diode_pd2nw_03v3 pj=40p area=99.99999p
D26 deepseek_vref vdd diode_pd2nw_03v3 pj=40p area=99.99999p
X57 strongarm_comparator$2_0.OUTN io_secondary_3p3_3.ASIG5V vdd vdd pfet_03v3 ad=1.8p pd=7.2u as=1.8p ps=7.2u w=3u l=0.5u
D27 gpt_cmp vdd diode_pd2nw_03v3 pj=40p area=99.99999p
X58 a_444522_318971# a_444522_318971# vss vss nfet_03v3 ad=0.6p pd=3.2u as=0.6p ps=3.2u w=1u l=4u
D28 vss clk diode_nd2ps_03v3 pj=40p area=99.99999p
D29 vss inp diode_nd2ps_03v3 pj=40p area=99.99999p
D30 deepseek_ota vdd diode_pd2nw_03v3 pj=40p area=99.99999p
X59 io_secondary_3p3_10.ASIG5V strongarm_comparator$2_0.INN a_449616_457872# vss nfet_03v3 ad=0.28p pd=1.56u as=0.28p ps=1.56u w=1u l=0.6u
X60 a_447160_411233# strongarm_comparator$2_0.CLK vss vss nfet_03v3 ad=0.28p pd=1.56u as=0.6p ps=3.2u w=1u l=0.6u
X61 a_446514_321988# a_444522_318971# a_446174_319178# vss nfet_03v3 ad=2.4p pd=9.2u as=2.4p ps=9.2u w=4u l=4u
X62 strongarm_comparator_0.OUTN strongarm_comparator$2_0.CLK vdd vdd pfet_03v3 ad=1.2p pd=5.2u as=1.2p ps=5.2u w=2u l=0.5u
X63 strongarm_comparator$3_0.OUTP strongarm_comparator$2_0.CLK vdd vdd pfet_03v3 ad=0.6p pd=3.2u as=0.28p ps=1.56u w=1u l=0.6u
X64 strongarm_comparator$3_0.OUTP strongarm_comparator$3_0.OUTN vdd vdd pfet_03v3 ad=0.28p pd=1.56u as=0.6p ps=3.2u w=1u l=0.6u
X65 io_secondary_3p3_4.ASIG5V io_secondary_3p3_4.ASIG5V a_450261_333180# vss nfet_03v3 ad=0.224p pd=1.36u as=0.224p ps=1.36u w=0.8u l=0.35u
X66 vdd a_449590_375410# io_secondary_3p3_2.ASIG5V vdd pfet_03v3 ad=2.4p pd=9.2u as=1.12p ps=4.56u w=4u l=2u
D31 inp vdd diode_pd2nw_03v3 pj=40p area=99.99999p
X67 io_secondary_3p3_10.ASIG5V a_449526_465503# vdd vdd pfet_03v3 ad=0.42p pd=2.06u as=0.42p ps=2.06u w=1.5u l=0.8u
X68 io_secondary_3p3_10.ASIG5V gpt_ota vdd ppolyf_u r_width=40u r_length=10u
X69 a_450261_333180# io_secondary_3p3_4.ASIG5V io_secondary_3p3_4.ASIG5V vss nfet_03v3 ad=0.224p pd=1.36u as=0.224p ps=1.36u w=0.8u l=0.35u
D32 vss ibias diode_nd2ps_03v3 pj=40p area=99.99999p
D33 vss inn diode_nd2ps_03v3 pj=40p area=99.99999p
X70 a_449526_465503# a_449526_465503# vdd vdd pfet_03v3 ad=0.42p pd=2.06u as=0.42p ps=2.06u w=1.5u l=0.8u
X71 vdd io_secondary_3p3_8.ASIG5V strongarm_comparator_0.OUTN vdd pfet_03v3 ad=0.56p pd=2.56u as=0.56p ps=2.56u w=2u l=0.5u
X72 a_450384_431778# strongarm_comparator$2_0.INP a_446992_431778# vss nfet_03v3 ad=1.2p pd=5.2u as=0.56p ps=2.56u w=2u l=0.6u
D34 oxa_ota vdd diode_pd2nw_03v3 pj=40p area=99.99999p
X73 a_446174_319178# vss vss ppolyf_u r_width=1u r_length=100u
X74 a_445142_322198# a_444522_318971# vss vss nfet_03v3 ad=2.4p pd=9.2u as=2.4p ps=9.2u w=4u l=0.6u
X75 a_449590_375410# a_449590_375410# vdd vdd pfet_03v3 ad=0.56p pd=2.56u as=1.2p ps=5.2u w=2u l=2u
D35 vss clk diode_nd2ps_03v3 pj=40p area=99.99999p
X76 a_446966_452332# strongarm_comparator$2_0.INN a_450032_449122# vss nfet_03v3 ad=3.6p pd=13.2u as=3.6p ps=13.2u w=6u l=2u
X77 io_secondary_3p3_8.ASIG5V strongarm_comparator$2_0.CLK vdd vdd pfet_03v3 ad=1.2p pd=5.2u as=1.2p ps=5.2u w=2u l=0.5u
D36 vss oxa_cmp diode_nd2ps_03v3 pj=40p area=99.99999p
X78 a_449296_472055# vref_1v2$2_0.IBIAS vss vss nfet_03v3 ad=0.56p pd=2.56u as=1.2p ps=5.2u w=2u l=1u
X79 a_450384_431778# strongarm_comparator$2_0.INN a_448488_431778# vss nfet_03v3 ad=1.2p pd=5.2u as=0.56p ps=2.56u w=2u l=0.6u
D37 gpt_cmp vdd diode_pd2nw_03v3 pj=40p area=99.99999p
X80 vdd a_446966_452332# ota$2_0.OUT vdd pfet_03v3 ad=2.1p pd=8.06u as=2.1p ps=8.06u w=7.5u l=4u
X81 strongarm_comparator$3_0.OUTP strongarm_comparator$3_0.OUTN a_447764_415153# vss nfet_03v3 ad=0.6p pd=3.2u as=0.28p ps=1.56u w=1u l=0.6u
X82 a_450261_333180# io_secondary_3p3_4.ASIG5V io_secondary_3p3_4.ASIG5V vss nfet_03v3 ad=0.224p pd=1.36u as=0.224p ps=1.36u w=0.8u l=0.35u
X83 a_446992_431778# strongarm_comparator$2_0.INP a_450384_431778# vss nfet_03v3 ad=0.56p pd=2.56u as=0.56p ps=2.56u w=2u l=0.6u
D38 vss gpt_cmp diode_nd2ps_03v3 pj=40p area=99.99999p
X84 vref_1v2$2_0.IBIAS vref_1v2$2_0.IBIAS vdd vdd pfet_03v3 ad=1.2p pd=5.2u as=1.2p ps=5.2u w=2u l=8u
X85 vref_1v2$2_0.IBIAS vref_1v2$2_0.IBIAS vss vss nfet_03v3 ad=0.56p pd=2.56u as=1.2p ps=5.2u w=2u l=2u
X86 temp_sensor_0.TEMP_OUT a_451730_316152# vss vss nfet_03v3 ad=1.8p pd=7.2u as=1.8p ps=7.2u w=3u l=1u
X87 vdd a_449366_474266# a_449366_474266# vdd pfet_03v3 ad=0.36p pd=2.4u as=0.168p ps=1.16u w=0.6u l=1u
X88 a_447764_415153# strongarm_comparator$2_0.CLK vdd vdd pfet_03v3 ad=0.6p pd=3.2u as=0.28p ps=1.56u w=1u l=0.6u
D39 deepseek_cmp vdd diode_pd2nw_03v3 pj=40p area=99.99999p
X89 a_451058_322196# temp_sensor_0.TEMP_OUT a_448866_319178# vss nfet_03v3 ad=2.4p pd=9.2u as=2.4p ps=9.2u w=4u l=0.6u
X90 a_449526_465503# a_449526_465503# vdd vdd pfet_03v3 ad=0.42p pd=2.06u as=0.9p ps=4.2u w=1.5u l=0.8u
X91 io_secondary_3p3_8.ASIG5V strongarm_comparator_0.OUTN vdd vdd pfet_03v3 ad=0.56p pd=2.56u as=1.2p ps=5.2u w=2u l=0.5u
D40 vss oxa_vref diode_nd2ps_03v3 pj=40p area=99.99999p
D41 vss deepseek_vref diode_nd2ps_03v3 pj=40p area=99.99999p
X92 a_449296_472055# strongarm_comparator$2_0.INP a_449366_474266# vss nfet_03v3 ad=0.28p pd=1.56u as=0.28p ps=1.56u w=1u l=1u
X93 a_449296_472055# vref_1v2$2_0.IBIAS vss vss nfet_03v3 ad=0.56p pd=2.56u as=0.56p ps=2.56u w=2u l=1u
X94 vss vref_1v2$2_0.IBIAS vref_1v2$2_0.IBIAS vss nfet_03v3 ad=0.28p pd=1.56u as=0.28p ps=1.56u w=1u l=1u
X95 a_449616_457872# vref_1v2$2_0.IBIAS vss vss nfet_03v3 ad=0.28p pd=1.56u as=0.6p ps=3.2u w=1u l=1u
X96 a_446992_431778# strongarm_comparator$2_0.INP a_450384_431778# vss nfet_03v3 ad=0.56p pd=2.56u as=0.56p ps=2.56u w=2u l=0.6u
D42 temp_out vdd diode_pd2nw_03v3 pj=40p area=99.99999p
X97 a_450261_333180# io_secondary_3p3_4.ASIG5V io_secondary_3p3_4.ASIG5V vss nfet_03v3 ad=0.224p pd=1.36u as=0.224p ps=1.36u w=0.8u l=0.35u
X98 vdd a_449366_474266# a_449366_474266# vdd pfet_03v3 ad=0.168p pd=1.16u as=0.168p ps=1.16u w=0.6u l=1u
X99 ota_0.OUT a_449366_474266# vdd vdd pfet_03v3 ad=0.168p pd=1.16u as=0.36p ps=2.4u w=0.6u l=1u
X100 io_secondary_3p3_10.ASIG5V a_449526_465503# vdd vdd pfet_03v3 ad=0.42p pd=2.06u as=0.9p ps=4.2u w=1.5u l=0.8u
X101 a_453622_319179# a_451058_322196# vss vss nfet_03v3 ad=0.6p pd=3.2u as=0.6p ps=3.2u w=1u l=4u
D43 oxa_cmp vdd diode_pd2nw_03v3 pj=40p area=99.99999p
X102 ota_0.OUT strongarm_comparator$2_0.INN a_449296_472055# vss nfet_03v3 ad=0.28p pd=1.56u as=0.6p ps=3.2u w=1u l=1u
X103 a_446514_321988# a_446514_321988# vdd vdd pfet_03v3 ad=2.4p pd=9.2u as=2.4p ps=9.2u w=4u l=4u
X104 io_secondary_3p3_4.ASIG5V io_secondary_3p3_4.ASIG5V a_450261_333180# vss nfet_03v3 ad=0.224p pd=1.36u as=0.224p ps=1.36u w=0.8u l=0.35u
X105 a_448488_431778# strongarm_comparator$2_0.INN a_450384_431778# vss nfet_03v3 ad=0.56p pd=2.56u as=1.2p ps=5.2u w=2u l=0.6u
X106 vdd strongarm_comparator$3_0.OUTP strongarm_comparator$3_0.OUTN vdd pfet_03v3 ad=0.28p pd=1.56u as=0.28p ps=1.56u w=1u l=0.6u
X107 io_secondary_3p3_2.ASIG5V deepseek_vref vdd ppolyf_u r_width=40u r_length=10u
X108 ota_0.OUT deepseek_ota vdd ppolyf_u r_width=40u r_length=10u
X109 a_445142_322198# vss vdd vdd pfet_03v3 ad=0.36p pd=2.4u as=0.36p ps=2.4u w=0.6u l=9.5u
X110 a_449616_457872# strongarm_comparator$2_0.INP a_449526_465503# vss nfet_03v3 ad=0.28p pd=1.56u as=0.28p ps=1.56u w=1u l=0.6u
D44 vss oxa_ota diode_nd2ps_03v3 pj=40p area=99.99999p
X111 a_447764_415153# strongarm_comparator$3_0.OUTN strongarm_comparator$3_0.OUTP vss nfet_03v3 ad=0.28p pd=1.56u as=0.28p ps=1.56u w=1u l=0.6u
D45 vss gpt_cmp diode_nd2ps_03v3 pj=40p area=99.99999p
D46 vss deepseek_ota diode_nd2ps_03v3 pj=40p area=99.99999p
X112 vdd a_449526_465503# io_secondary_3p3_10.ASIG5V vdd pfet_03v3 ad=0.9p pd=4.2u as=0.42p ps=2.06u w=1.5u l=0.8u
D47 deepseek_cmp vdd diode_pd2nw_03v3 pj=40p area=99.99999p
D48 gpt_vref vdd diode_pd2nw_03v3 pj=40p area=99.99999p
D49 gpt_ota vdd diode_pd2nw_03v3 pj=40p area=99.99999p
X113 strongarm_comparator$3_0.OUTN strongarm_comparator$3_0.OUTP vdd vdd pfet_03v3 ad=0.28p pd=1.56u as=0.6p ps=3.2u w=1u l=0.6u
X114 vss strongarm_comparator$2_0.CLK a_447160_411233# vss nfet_03v3 ad=0.28p pd=1.56u as=0.28p ps=1.56u w=1u l=0.6u
X115 a_449296_472055# strongarm_comparator$2_0.INP a_449366_474266# vss nfet_03v3 ad=0.6p pd=3.2u as=0.28p ps=1.56u w=1u l=1u
X116 strongarm_comparator$3_0.OUTN strongarm_comparator$2_0.CLK vdd vdd pfet_03v3 ad=0.28p pd=1.56u as=0.6p ps=3.2u w=1u l=0.6u
X117 vdd strongarm_comparator$3_0.OUTN strongarm_comparator$3_0.OUTP vdd pfet_03v3 ad=0.28p pd=1.56u as=0.28p ps=1.56u w=1u l=0.6u
X118 a_447160_411233# strongarm_comparator$2_0.INN a_447764_415153# vss nfet_03v3 ad=0.28p pd=1.56u as=0.28p ps=1.56u w=1u l=0.6u
X119 ibias vref_1v2$2_0.IBIAS vdd ppolyf_u r_width=40u r_length=10u
X120 a_449616_457872# vref_1v2$2_0.IBIAS vss vss nfet_03v3 ad=0.28p pd=1.56u as=0.28p ps=1.56u w=1u l=1u
X121 vss a_451730_316152# a_454802_322196# vdd pfet_03v3 ad=2.4p pd=9.2u as=2.4p ps=9.2u w=4u l=4u
X122 io_secondary_3p3_4.ASIG5V io_secondary_3p3_4.ASIG5V a_450261_333180# vss nfet_03v3 ad=0.224p pd=1.36u as=0.224p ps=1.36u w=0.8u l=0.35u
X123 io_secondary_3p3_8.ASIG5V strongarm_comparator_0.OUTN a_448488_431778# vss nfet_03v3 ad=1.2p pd=5.2u as=0.56p ps=2.56u w=2u l=0.5u
D50 temp_out vdd diode_pd2nw_03v3 pj=40p area=99.99999p
D51 inn vdd diode_pd2nw_03v3 pj=40p area=99.99999p
D52 vss temp_out diode_nd2ps_03v3 pj=40p area=99.99999p
X124 a_448866_319178# a_444522_318971# vss vss nfet_03v3 ad=1.2p pd=5.2u as=1.2p ps=5.2u w=2u l=4u
D53 vss deepseek_cmp diode_nd2ps_03v3 pj=40p area=99.99999p
X125 strongarm_comparator$3_0.OUTN strongarm_comparator$3_0.OUTP vdd vdd pfet_03v3 ad=0.6p pd=3.2u as=0.28p ps=1.56u w=1u l=0.6u
X126 a_446514_321988# a_445142_322198# vss vss nfet_03v3 ad=0.6p pd=3.2u as=0.6p ps=3.2u w=1u l=1u
X127 vref_1v2$2_0.IBIAS vref_1v2$2_0.IBIAS vdd vdd pfet_03v3 ad=1.2p pd=5.2u as=1.2p ps=5.2u w=2u l=8u
X128 inp strongarm_comparator$2_0.INP vdd ppolyf_u r_width=40u r_length=10u
D54 oxa_vref vdd diode_pd2nw_03v3 pj=40p area=99.99999p
X129 a_448488_431778# strongarm_comparator$2_0.INN a_450384_431778# vss nfet_03v3 ad=0.56p pd=2.56u as=0.56p ps=2.56u w=2u l=0.6u
X130 io_secondary_3p3_4.ASIG5V vref_1v2$2_0.IBIAS vdd vdd pfet_03v3 ad=1.2p pd=5.2u as=1.2p ps=5.2u w=2u l=8u
X131 io_secondary_3p3_2.ASIG5V a_449590_375410# vdd vdd pfet_03v3 ad=1.12p pd=4.56u as=2.4p ps=9.2u w=4u l=2u
D55 clk vdd diode_pd2nw_03v3 pj=40p area=99.99999p
X132 vdd a_449590_375410# a_449590_375410# vdd pfet_03v3 ad=1.2p pd=5.2u as=0.56p ps=2.56u w=2u l=2u
X133 ota_0.OUT a_449366_474266# vdd vdd pfet_03v3 ad=0.168p pd=1.16u as=0.168p ps=1.16u w=0.6u l=1u
X134 ota_0.OUT strongarm_comparator$2_0.INN a_449296_472055# vss nfet_03v3 ad=0.28p pd=1.56u as=0.28p ps=1.56u w=1u l=1u
X135 strongarm_comparator_0.OUTN io_secondary_3p3_8.ASIG5V vdd vdd pfet_03v3 ad=1.2p pd=5.2u as=0.56p ps=2.56u w=2u l=0.5u
D56 ibias vdd diode_pd2nw_03v3 pj=40p area=99.99999p
X136 vdd a_451730_316152# a_453622_319179# vss nfet_03v3 ad=1.2p pd=5.2u as=1.2p ps=5.2u w=2u l=4u
D57 vss inp diode_nd2ps_03v3 pj=40p area=99.99999p
D58 oxa_ota vdd diode_pd2nw_03v3 pj=40p area=99.99999p
X137 io_secondary_3p3_3.ASIG5V oxa_cmp vdd ppolyf_u r_width=40u r_length=10u
D59 inp vdd diode_pd2nw_03v3 pj=40p area=99.99999p
D60 vss ibias diode_nd2ps_03v3 pj=40p area=99.99999p
D61 vss temp_out diode_nd2ps_03v3 pj=40p area=99.99999p
X138 a_446966_452332# a_446966_452332# vdd vdd pfet_03v3 ad=2.1p pd=8.06u as=4.5p ps=16.2u w=7.5u l=4u
X139 a_450384_431778# strongarm_comparator$2_0.INP a_446992_431778# vss nfet_03v3 ad=0.56p pd=2.56u as=0.56p ps=2.56u w=2u l=0.6u
D62 vss deepseek_cmp diode_nd2ps_03v3 pj=40p area=99.99999p
D63 vss gpt_vref diode_nd2ps_03v3 pj=40p area=99.99999p
D64 vss oxa_cmp diode_nd2ps_03v3 pj=40p area=99.99999p
D65 vss inn diode_nd2ps_03v3 pj=40p area=99.99999p
D66 vss gpt_ota diode_nd2ps_03v3 pj=40p area=99.99999p
D67 oxa_vref vdd diode_pd2nw_03v3 pj=40p area=99.99999p
X140 vss vref_1v2$2_0.IBIAS vref_1v2$2_0.IBIAS vss nfet_03v3 ad=0.6p pd=3.2u as=0.28p ps=1.56u w=1u l=1u
X141 a_446992_431778# strongarm_comparator$2_0.CLK vdd vdd pfet_03v3 ad=1.2p pd=5.2u as=1.2p ps=5.2u w=2u l=0.5u
X142 a_446992_431778# io_secondary_3p3_8.ASIG5V strongarm_comparator_0.OUTN vss nfet_03v3 ad=0.56p pd=2.56u as=0.56p ps=2.56u w=2u l=0.5u
D68 gpt_cmp vdd diode_pd2nw_03v3 pj=40p area=99.99999p
D69 deepseek_vref vdd diode_pd2nw_03v3 pj=40p area=99.99999p
D70 deepseek_ota vdd diode_pd2nw_03v3 pj=40p area=99.99999p
X143 a_450384_431778# strongarm_comparator$2_0.INN a_448488_431778# vss nfet_03v3 ad=0.56p pd=2.56u as=0.56p ps=2.56u w=2u l=0.6u
X144 io_secondary_3p3_4.ASIG5V io_secondary_3p3_4.ASIG5V a_450261_333180# vss nfet_03v3 ad=0.224p pd=1.36u as=0.224p ps=1.36u w=0.8u l=0.35u
D71 vss clk diode_nd2ps_03v3 pj=40p area=99.99999p
X145 a_450261_333180# io_secondary_3p3_4.ASIG5V io_secondary_3p3_4.ASIG5V vss nfet_03v3 ad=0.224p pd=1.36u as=0.224p ps=1.36u w=0.8u l=0.35u
D72 vss ibias diode_nd2ps_03v3 pj=40p area=99.99999p
X146 a_447764_415153# strongarm_comparator$2_0.CLK vdd vdd pfet_03v3 ad=0.28p pd=1.56u as=0.6p ps=3.2u w=1u l=0.6u
D73 vss oxa_vref diode_nd2ps_03v3 pj=40p area=99.99999p
D74 oxa_ota vdd diode_pd2nw_03v3 pj=40p area=99.99999p
X147 vdd strongarm_comparator$2_0.CLK strongarm_comparator$3_0.OUTN vdd pfet_03v3 ad=0.28p pd=1.56u as=0.28p ps=1.56u w=1u l=0.6u
X148 strongarm_comparator$3_0.OUTP strongarm_comparator$3_0.OUTN vdd vdd pfet_03v3 ad=0.6p pd=3.2u as=0.28p ps=1.56u w=1u l=0.6u
X149 vss vref_1v2$2_0.IBIAS a_449590_375410# vss nfet_03v3 ad=1.2p pd=5.2u as=0.56p ps=2.56u w=2u l=2u
X150 vss vref_1v2$2_0.IBIAS a_449296_472055# vss nfet_03v3 ad=0.56p pd=2.56u as=0.56p ps=2.56u w=2u l=1u
X151 a_448488_431778# strongarm_comparator_0.OUTN io_secondary_3p3_8.ASIG5V vss nfet_03v3 ad=0.56p pd=2.56u as=0.56p ps=2.56u w=2u l=0.5u
X152 strongarm_comparator$3_0.OUTN strongarm_comparator$3_0.OUTP a_446108_415153# vss nfet_03v3 ad=0.28p pd=1.56u as=0.6p ps=3.2u w=1u l=0.6u
X153 vref_1v2$1_0.VREF vref_1v2$2_0.IBIAS vdd vdd pfet_03v3 ad=1.2p pd=5.2u as=1.2p ps=5.2u w=2u l=8u
X154 ota$2_0.OUT a_446966_452332# vdd vdd pfet_03v3 ad=2.1p pd=8.06u as=4.5p ps=16.2u w=7.5u l=4u
X155 vref_1v2$2_0.IBIAS vref_1v2$2_0.IBIAS vss vss nfet_03v3 ad=1.2p pd=5.2u as=1.2p ps=5.2u w=2u l=2u
X156 vdd strongarm_comparator$2_0.CLK a_446108_415153# vdd pfet_03v3 ad=0.28p pd=1.56u as=0.28p ps=1.56u w=1u l=0.6u
X157 a_447858_395380# strongarm_comparator$2_0.CLK vdd vdd pfet_03v3 ad=0.48p pd=2.8u as=0.48p ps=2.8u w=0.8u l=0.5u
X158 a_449590_375410# vref_1v2$2_0.IBIAS vss vss nfet_03v3 ad=0.56p pd=2.56u as=1.2p ps=5.2u w=2u l=2u
D75 vss gpt_cmp diode_nd2ps_03v3 pj=40p area=99.99999p
X159 io_secondary_3p3_3.ASIG5V strongarm_comparator$2_0.OUTN a_449030_395380# vss nfet_03v3 ad=1.38p pd=5.8u as=1.38p ps=5.8u w=2.3u l=0.5u
X160 temp_sensor_0.TEMP_OUT a_451730_316152# vdd vdd pfet_03v3 ad=3.6p pd=13.2u as=3.6p ps=13.2u w=6u l=1u
D76 vss oxa_ota diode_nd2ps_03v3 pj=40p area=99.99999p
D77 deepseek_cmp vdd diode_pd2nw_03v3 pj=40p area=99.99999p
D78 gpt_vref vdd diode_pd2nw_03v3 pj=40p area=99.99999p
D79 gpt_ota vdd diode_pd2nw_03v3 pj=40p area=99.99999p
D80 vss oxa_vref diode_nd2ps_03v3 pj=40p area=99.99999p
X161 strongarm_comparator$2_0.OUTN io_secondary_3p3_3.ASIG5V a_447858_395380# vss nfet_03v3 ad=1.38p pd=5.8u as=1.38p ps=5.8u w=2.3u l=0.5u
D81 vss deepseek_vref diode_nd2ps_03v3 pj=40p area=99.99999p
X162 vdd a_449366_474266# ota_0.OUT vdd pfet_03v3 ad=0.168p pd=1.16u as=0.168p ps=1.16u w=0.6u l=1u
X163 vss vref_1v2$2_0.IBIAS a_449296_472055# vss nfet_03v3 ad=1.2p pd=5.2u as=0.56p ps=2.56u w=2u l=1u
X164 vss vref_1v2$2_0.IBIAS a_449616_457872# vss nfet_03v3 ad=0.28p pd=1.56u as=0.28p ps=1.56u w=1u l=1u
X165 vdd strongarm_comparator_0.OUTN io_secondary_3p3_8.ASIG5V vdd pfet_03v3 ad=0.56p pd=2.56u as=0.56p ps=2.56u w=2u l=0.5u
D82 temp_out vdd diode_pd2nw_03v3 pj=40p area=99.99999p
X166 a_451730_316152# a_451058_322196# a_453622_319179# vss nfet_03v3 ad=0.6p pd=3.2u as=0.6p ps=3.2u w=1u l=4u
X167 a_449296_472055# strongarm_comparator$2_0.INN ota_0.OUT vss nfet_03v3 ad=0.28p pd=1.56u as=0.28p ps=1.56u w=1u l=1u
X168 vdd a_446966_452332# a_446966_452332# vdd pfet_03v3 ad=4.5p pd=16.2u as=2.1p ps=8.06u w=7.5u l=4u
D83 oxa_cmp vdd diode_pd2nw_03v3 pj=40p area=99.99999p
X169 vref_1v2$2_0.IBIAS vref_1v2$2_0.IBIAS vss vss nfet_03v3 ad=0.28p pd=1.56u as=0.6p ps=3.2u w=1u l=1u
X170 a_446108_415153# strongarm_comparator$2_0.INP a_447160_411233# vss nfet_03v3 ad=0.28p pd=1.56u as=0.6p ps=3.2u w=1u l=0.6u
X171 a_446992_431778# strongarm_comparator$2_0.INP a_450384_431778# vss nfet_03v3 ad=0.56p pd=2.56u as=0.56p ps=2.56u w=2u l=0.6u
X172 strongarm_comparator$3_0.OUTP gpt_cmp vdd ppolyf_u r_width=40u r_length=10u
D84 vss deepseek_ota diode_nd2ps_03v3 pj=40p area=99.99999p
D85 vss oxa_ota diode_nd2ps_03v3 pj=40p area=99.99999p
D86 inn vdd diode_pd2nw_03v3 pj=40p area=99.99999p
X173 a_448488_431778# strongarm_comparator$2_0.INN a_450384_431778# vss nfet_03v3 ad=0.56p pd=2.56u as=0.56p ps=2.56u w=2u l=0.6u
D87 gpt_vref vdd diode_pd2nw_03v3 pj=40p area=99.99999p
D88 gpt_ota vdd diode_pd2nw_03v3 pj=40p area=99.99999p
X174 vss vref_1v2$2_0.IBIAS a_449616_457872# vss nfet_03v3 ad=0.6p pd=3.2u as=0.28p ps=1.56u w=1u l=1u
X175 strongarm_comparator$3_0.OUTN strongarm_comparator$3_0.OUTP a_446108_415153# vss nfet_03v3 ad=0.28p pd=1.56u as=0.28p ps=1.56u w=1u l=0.6u
D89 clk vdd diode_pd2nw_03v3 pj=40p area=99.99999p
X176 vdd strongarm_comparator$2_0.CLK strongarm_comparator$3_0.OUTP vdd pfet_03v3 ad=0.28p pd=1.56u as=0.28p ps=1.56u w=1u l=0.6u
X177 a_447764_415153# strongarm_comparator$2_0.INN a_447160_411233# vss nfet_03v3 ad=0.28p pd=1.56u as=0.6p ps=3.2u w=1u l=0.6u
X178 a_449574_352580# vref_1v2$1_0.VREF vss vss nfet_03v3 ad=5.7p pd=20.2u as=5.7p ps=20.2u w=9.5u l=8u
X179 a_446108_415153# strongarm_comparator$2_0.CLK vdd vdd pfet_03v3 ad=0.28p pd=1.56u as=0.6p ps=3.2u w=1u l=0.6u
X180 io_secondary_3p3_10.ASIG5V strongarm_comparator$2_0.INN a_449616_457872# vss nfet_03v3 ad=0.28p pd=1.56u as=0.6p ps=3.2u w=1u l=0.6u
X181 vdd strongarm_comparator$2_0.CLK a_447764_415153# vdd pfet_03v3 ad=0.28p pd=1.56u as=0.28p ps=1.56u w=1u l=0.6u
X182 strongarm_comparator$3_0.OUTN strongarm_comparator$2_0.CLK vdd vdd pfet_03v3 ad=0.6p pd=3.2u as=0.28p ps=1.56u w=1u l=0.6u
X183 a_447160_411233# strongarm_comparator$2_0.INP a_446108_415153# vss nfet_03v3 ad=0.28p pd=1.56u as=0.28p ps=1.56u w=1u l=0.6u
D90 vss temp_out diode_nd2ps_03v3 pj=40p area=99.99999p
X184 a_450261_333180# io_secondary_3p3_4.ASIG5V io_secondary_3p3_4.ASIG5V vss nfet_03v3 ad=0.224p pd=1.36u as=0.224p ps=1.36u w=0.8u l=0.35u
X185 a_449020_392562# strongarm_comparator$2_0.CLK vss vss nfet_03v3 ad=5.46p pd=19.4u as=5.46p ps=19.4u w=9.1u l=0.5u
D91 ibias vdd diode_pd2nw_03v3 pj=40p area=99.99999p
X186 vdd a_446966_452332# ota$2_0.OUT vdd pfet_03v3 ad=4.5p pd=16.2u as=2.1p ps=8.06u w=7.5u l=4u
D92 vss deepseek_cmp diode_nd2ps_03v3 pj=40p area=99.99999p
D93 vss gpt_vref diode_nd2ps_03v3 pj=40p area=99.99999p
X187 vss vref_1v2$2_0.IBIAS vref_1v2$2_0.IBIAS vss nfet_03v3 ad=0.6p pd=3.2u as=0.28p ps=1.56u w=1u l=1u
D94 vss gpt_ota diode_nd2ps_03v3 pj=40p area=99.99999p
D95 inn vdd diode_pd2nw_03v3 pj=40p area=99.99999p
D96 vss inp diode_nd2ps_03v3 pj=40p area=99.99999p
X188 a_449526_465503# strongarm_comparator$2_0.INP a_449616_457872# vss nfet_03v3 ad=0.28p pd=1.56u as=0.28p ps=1.56u w=1u l=0.6u
D97 oxa_vref vdd diode_pd2nw_03v3 pj=40p area=99.99999p
D98 deepseek_vref vdd diode_pd2nw_03v3 pj=40p area=99.99999p
D99 deepseek_ota vdd diode_pd2nw_03v3 pj=40p area=99.99999p
X189 a_447764_415153# strongarm_comparator$2_0.INN a_447160_411233# vss nfet_03v3 ad=0.6p pd=3.2u as=0.28p ps=1.56u w=1u l=0.6u
X190 strongarm_comparator$2_0.OUTN strongarm_comparator$2_0.CLK vdd vdd pfet_03v3 ad=0.96p pd=4.4u as=0.96p ps=4.4u w=1.6u l=0.5u
D100 inp vdd diode_pd2nw_03v3 pj=40p area=99.99999p
X191 a_450384_431778# strongarm_comparator$2_0.INN a_448488_431778# vss nfet_03v3 ad=0.56p pd=2.56u as=0.56p ps=2.56u w=2u l=0.6u
X192 a_446108_415153# strongarm_comparator$2_0.CLK vdd vdd pfet_03v3 ad=0.6p pd=3.2u as=0.28p ps=1.56u w=1u l=0.6u
X193 strongarm_comparator$3_0.OUTP strongarm_comparator$3_0.OUTN a_447764_415153# vss nfet_03v3 ad=0.28p pd=1.56u as=0.6p ps=3.2u w=1u l=0.6u
X194 a_451730_316152# a_451058_322196# a_454802_322196# vdd pfet_03v3 ad=1.2p pd=5.2u as=1.2p ps=5.2u w=2u l=4u
X195 strongarm_comparator_0.OUTN io_secondary_3p3_8.ASIG5V vdd vdd pfet_03v3 ad=0.56p pd=2.56u as=1.2p ps=5.2u w=2u l=0.5u
X196 io_secondary_3p3_8.ASIG5V deepseek_cmp vdd ppolyf_u r_width=40u r_length=10u
D101 clk vdd diode_pd2nw_03v3 pj=40p area=99.99999p
D102 vss inn diode_nd2ps_03v3 pj=40p area=99.99999p
X197 vref_1v2$2_0.IBIAS vref_1v2$2_0.IBIAS vss vss nfet_03v3 ad=0.28p pd=1.56u as=0.28p ps=1.56u w=1u l=1u
X198 a_446108_415153# strongarm_comparator$3_0.OUTP strongarm_comparator$3_0.OUTN vss nfet_03v3 ad=0.28p pd=1.56u as=0.28p ps=1.56u w=1u l=0.6u
D103 oxa_ota vdd diode_pd2nw_03v3 pj=40p area=99.99999p
X199 temp_sensor_0.TEMP_OUT temp_out vdd ppolyf_u r_width=40u r_length=10u
D104 vss clk diode_nd2ps_03v3 pj=40p area=99.99999p
X200 strongarm_comparator$3_0.OUTP strongarm_comparator$3_0.OUTN a_447764_415153# vss nfet_03v3 ad=0.28p pd=1.56u as=0.28p ps=1.56u w=1u l=0.6u
X201 io_secondary_3p3_3.ASIG5V strongarm_comparator$2_0.CLK vdd vdd pfet_03v3 ad=0.96p pd=4.4u as=0.96p ps=4.4u w=1.6u l=0.5u
X202 a_446992_431778# strongarm_comparator$2_0.INP a_450384_431778# vss nfet_03v3 ad=0.56p pd=2.56u as=1.2p ps=5.2u w=2u l=0.6u
D105 vss gpt_vref diode_nd2ps_03v3 pj=40p area=99.99999p
D106 vss oxa_cmp diode_nd2ps_03v3 pj=40p area=99.99999p
D107 vss gpt_ota diode_nd2ps_03v3 pj=40p area=99.99999p
X203 io_secondary_3p3_8.ASIG5V strongarm_comparator_0.OUTN a_448488_431778# vss nfet_03v3 ad=0.56p pd=2.56u as=1.2p ps=5.2u w=2u l=0.5u
D108 vss ibias diode_nd2ps_03v3 pj=40p area=99.99999p
D109 deepseek_vref vdd diode_pd2nw_03v3 pj=40p area=99.99999p
D110 deepseek_ota vdd diode_pd2nw_03v3 pj=40p area=99.99999p
X204 a_448488_431778# strongarm_comparator$2_0.CLK vdd vdd pfet_03v3 ad=1.2p pd=5.2u as=1.2p ps=5.2u w=2u l=0.5u
D111 gpt_cmp vdd diode_pd2nw_03v3 pj=40p area=99.99999p
C0 a_454802_322196# vdd 3.72699f
C1 io_secondary_3p3_8.ASIG5V strongarm_comparator_0.OUTN 2.66446f
C2 a_447160_411233# a_447764_415153# 1.37005f
C3 strongarm_comparator_0.OUTN a_446992_431778# 2.02404f
C4 a_447764_415153# strongarm_comparator$2_0.CLK 0.37018f
C5 vdd a_445142_322198# 2.96508f
C6 a_444522_318971# a_446174_319178# 0.85674f
C7 a_446966_452332# ota$2_0.OUT 2.4919f
C8 a_447858_395380# strongarm_comparator$2_0.OUTN 0.63663f
C9 vdd oxa_vref 54.2263f
C10 a_446108_415153# strongarm_comparator$2_0.INP 0.18443f
C11 io_secondary_3p3_3.ASIG5V vdd 23.8466f
C12 io_secondary_3p3_8.ASIG5V strongarm_comparator$2_0.CLK 0.98117f
C13 oxa_cmp vdd 54.2263f
C14 strongarm_comparator$3_0.OUTP vdd 25.6301f
C15 ota$2_0.OUT a_450032_449122# 0.64531f
C16 a_446992_431778# strongarm_comparator$2_0.CLK 0.28267f
C17 a_449020_392562# a_449030_395380# 1.00181f
C18 strongarm_comparator$2_0.INP a_448488_431778# 0.06078f
C19 a_449616_457872# vref_1v2$2_0.IBIAS 0.43888f
C20 a_449030_395380# strongarm_comparator$2_0.CLK 0.29164f
C21 a_445142_322198# a_448866_319178# 0.44392f
C22 a_445142_322198# a_446514_321988# 0.80509f
C23 temp_sensor_0.TEMP_OUT vdd 21.8421f
C24 vdd a_449366_474266# 9.04042f
C25 strongarm_comparator$2_0.INN a_449616_457872# 0.3586f
C26 a_447858_395380# strongarm_comparator$2_0.INP 0.08248f
C27 vdd gpt_vref 54.2263f
C28 inn vdd 54.2263f
C29 strongarm_comparator$2_0.INP ota$2_0.OUT 0.39351f
C30 strongarm_comparator_0.OUTN a_448488_431778# 0.65529f
C31 vref_1v2$2_0.IBIAS vdd 63.2937f
C32 strongarm_comparator$2_0.INN a_449366_474266# 0.01597f
C33 io_secondary_3p3_3.ASIG5V strongarm_comparator$2_0.OUTN 2.4802f
C34 inp vdd 54.2263f
C35 a_447160_411233# a_446108_415153# 1.36771f
C36 io_secondary_3p3_8.ASIG5V a_446992_431778# 0.62257f
C37 a_446108_415153# strongarm_comparator$2_0.CLK 0.30369f
C38 strongarm_comparator$2_0.INN vref_1v2$2_0.IBIAS 3.47636f
C39 temp_sensor_0.TEMP_OUT a_448866_319178# 0.12645f
C40 a_449526_465503# a_449616_457872# 1.58029f
C41 strongarm_comparator$2_0.INN vdd 28.2803f
C42 a_450261_333180# vdd 0.01823f
C43 temp_sensor_0.TEMP_OUT a_446514_321988# 0.03471f
C44 vdd deepseek_cmp 54.2263f
C45 a_450384_431778# strongarm_comparator$2_0.INN 0.93145f
C46 a_448488_431778# strongarm_comparator$2_0.CLK 0.49538f
C47 vdd clk 54.4801f
C48 a_446108_415153# a_447764_415153# 0.99149f
C49 vdd a_446514_321988# 10.7114f
C50 a_446966_452332# vdd 25.7127f
C51 vref_1v2$2_0.IBIAS vref_1v2$1_0.VREF 0.62612f
C52 a_449366_474266# a_449296_472055# 1.38238f
C53 a_449526_465503# vdd 8.66544f
C54 vdd vref_1v2$1_0.VREF 22.0073f
C55 a_451058_322196# a_454802_322196# 0.50803f
C56 a_449366_474266# ota_0.OUT 0.67284f
C57 vdd strongarm_comparator$2_0.OUTN 4.98631f
C58 a_447858_395380# a_449020_392562# 1.05329f
C59 strongarm_comparator$3_0.OUTN strongarm_comparator$2_0.CLK 0.21888f
C60 a_447858_395380# strongarm_comparator$2_0.CLK 0.25661f
C61 vref_1v2$2_0.IBIAS a_450032_449122# 0.84338f
C62 a_446966_452332# strongarm_comparator$2_0.INN 0.30502f
C63 vref_1v2$2_0.IBIAS a_449296_472055# 0.42473f
C64 strongarm_comparator$2_0.INP a_449616_457872# 0.53892f
C65 temp_sensor_0.TEMP_OUT a_453622_319179# 0.01731f
C66 vdd ota_0.OUT 21.8939f
C67 strongarm_comparator$2_0.INN a_450032_449122# 0.41863f
C68 a_448866_319178# a_446514_321988# 0.0476f
C69 strongarm_comparator$2_0.INP a_449366_474266# 0.27014f
C70 strongarm_comparator$2_0.INN a_449296_472055# 0.48669f
C71 strongarm_comparator$3_0.OUTN a_447764_415153# 0.58984f
C72 io_secondary_3p3_8.ASIG5V a_448488_431778# 1.91595f
C73 strongarm_comparator$2_0.INN ota_0.OUT 0.38251f
C74 a_453622_319179# vdd 0.71418f
C75 a_446992_431778# a_448488_431778# 0.93605f
C76 strongarm_comparator$2_0.INP vref_1v2$2_0.IBIAS 19.0447f
C77 strongarm_comparator$2_0.INP vdd 28.2803f
C78 a_446966_452332# a_450032_449122# 0.734f
C79 a_450384_431778# strongarm_comparator$2_0.INP 0.78207f
C80 a_451730_316152# a_454802_322196# 1.4225f
C81 temp_sensor_0.TEMP_OUT a_451058_322196# 1.53873f
C82 io_secondary_3p3_3.ASIG5V a_449020_392562# 0.04836f
C83 io_secondary_3p3_3.ASIG5V strongarm_comparator$2_0.CLK 0.11951f
C84 a_446174_319178# a_445142_322198# 0.18828f
C85 strongarm_comparator$2_0.INN strongarm_comparator$2_0.INP 39.8181f
C86 strongarm_comparator$3_0.OUTP strongarm_comparator$2_0.CLK 0.17786f
C87 io_secondary_3p3_2.ASIG5V vref_1v2$2_0.IBIAS 0.02814f
C88 deepseek_vref vdd 54.2263f
C89 a_444522_318971# a_445142_322198# 0.61741f
C90 io_secondary_3p3_2.ASIG5V vdd 20.8612f
C91 temp_out vdd 54.2263f
C92 a_447858_395380# a_449030_395380# 0.73046f
C93 strongarm_comparator_0.OUTN vdd 9.14528f
C94 a_451058_322196# vdd 8.64278f
C95 a_449296_472055# ota_0.OUT 1.42717f
C96 a_446966_452332# strongarm_comparator$2_0.INP 0.13598f
C97 gpt_ota vdd 54.2263f
C98 strongarm_comparator$3_0.OUTP a_447764_415153# 2.02651f
C99 a_449526_465503# strongarm_comparator$2_0.INP 0.26577f
C100 strongarm_comparator$2_0.INP a_450032_449122# 0.76388f
C101 vref_1v2$2_0.IBIAS strongarm_comparator$2_0.CLK 1.67993f
C102 strongarm_comparator$2_0.INP a_449296_472055# 0.86513f
C103 vdd strongarm_comparator$2_0.CLK 43.3578f
C104 a_451058_322196# a_448866_319178# 0.7544f
C105 a_449590_375410# vref_1v2$2_0.IBIAS 0.41001f
C106 temp_sensor_0.TEMP_OUT a_451730_316152# 0.54646f
C107 a_449590_375410# vdd 7.64579f
C108 strongarm_comparator$3_0.OUTN a_446108_415153# 1.83943f
C109 a_451058_322196# a_446514_321988# 0.26656f
C110 a_450384_431778# strongarm_comparator$2_0.CLK 0.62865f
C111 strongarm_comparator$2_0.INN a_449020_392562# 0.15018f
C112 a_447160_411233# strongarm_comparator$2_0.INN 0.38359f
C113 strongarm_comparator$2_0.INN strongarm_comparator$2_0.CLK 15.4831f
C114 io_secondary_3p3_3.ASIG5V a_449030_395380# 0.7538f
C115 a_444522_318971# vdd 2.41128f
C116 a_449574_352580# vdd 0.01369f
C117 a_447764_415153# vdd 2.58006f
C118 a_451730_316152# vdd 5.39078f
C119 strongarm_comparator$2_0.INN a_447764_415153# 0.20365f
C120 deepseek_ota vdd 54.2263f
C121 strongarm_comparator$2_0.CLK strongarm_comparator$2_0.OUTN 0.1727f
C122 io_secondary_3p3_8.ASIG5V vdd 27.2431f
C123 a_453622_319179# a_451058_322196# 0.48479f
C124 a_444522_318971# a_448866_319178# 0.18157f
C125 a_446174_319178# a_446514_321988# 0.63482f
C126 a_446992_431778# vdd 1.80229f
C127 ibias vdd 54.2263f
C128 strongarm_comparator_0.OUTN strongarm_comparator$2_0.INP 0.11248f
C129 a_444522_318971# a_446514_321988# 1.22898f
C130 a_450384_431778# io_secondary_3p3_8.ASIG5V 0.03264f
C131 a_449030_395380# vdd 1.68981f
C132 strongarm_comparator$3_0.OUTP a_446108_415153# 0.37272f
C133 a_450384_431778# a_446992_431778# 3.73892f
C134 strongarm_comparator$2_0.INN io_secondary_3p3_8.ASIG5V 0.0408f
C135 a_449574_352580# vref_1v2$1_0.VREF 2.78004f
C136 strongarm_comparator$2_0.INN a_446992_431778# 0.01484f
C137 io_secondary_3p3_4.ASIG5V vref_1v2$2_0.IBIAS 0.33406f
C138 io_secondary_3p3_10.ASIG5V a_449616_457872# 1.34454f
C139 io_secondary_3p3_4.ASIG5V vdd 21.5574f
C140 oxa_ota vdd 54.2263f
C141 strongarm_comparator$2_0.INN a_449030_395380# 0.11347f
C142 a_449020_392562# strongarm_comparator$2_0.INP 0.17906f
C143 a_447160_411233# strongarm_comparator$2_0.INP 0.36521f
C144 strongarm_comparator$2_0.INP strongarm_comparator$2_0.CLK 1.81732f
C145 io_secondary_3p3_4.ASIG5V a_450261_333180# 6.17729f
C146 io_secondary_3p3_3.ASIG5V a_447858_395380# 0.17181f
C147 strongarm_comparator$3_0.OUTN strongarm_comparator$3_0.OUTP 2.31353f
C148 io_secondary_3p3_10.ASIG5V vdd 21.5471f
C149 a_446108_415153# vdd 2.65684f
C150 a_453622_319179# a_451730_316152# 1.69852f
C151 a_449030_395380# strongarm_comparator$2_0.OUTN 0.23079f
C152 a_449590_375410# io_secondary_3p3_2.ASIG5V 0.59715f
C153 strongarm_comparator_0.OUTN strongarm_comparator$2_0.CLK 0.05446f
C154 strongarm_comparator$2_0.INN io_secondary_3p3_10.ASIG5V 0.31108f
C155 vdd a_448488_431778# 1.73701f
C156 strongarm_comparator$2_0.INN a_446108_415153# 0.04975f
C157 a_450384_431778# a_448488_431778# 4.17529f
C158 strongarm_comparator$2_0.INN a_448488_431778# 0.70772f
C159 io_secondary_3p3_8.ASIG5V strongarm_comparator$2_0.INP 0.20341f
C160 strongarm_comparator$2_0.INP a_446992_431778# 0.78694f
C161 strongarm_comparator$3_0.OUTN vdd 7.9219f
C162 a_447858_395380# vdd 1.7739f
C163 a_451058_322196# a_451730_316152# 1.0474f
C164 a_449526_465503# io_secondary_3p3_10.ASIG5V 0.6927f
C165 a_449020_392562# strongarm_comparator$2_0.CLK 0.49113f
C166 a_447160_411233# strongarm_comparator$2_0.CLK 0.4952f
C167 ota$2_0.OUT vdd 24.1166f
C168 gpt_cmp vdd 54.2263f
C169 a_449030_395380# strongarm_comparator$2_0.INP 0.02585f
C170 temp_out vss 0.16065p
C171 oxa_vref vss 0.16065p
C172 gpt_vref vss 0.16065p
C173 deepseek_vref vss 0.16065p
C174 oxa_cmp vss 0.16065p
C175 gpt_cmp vss 0.16065p
C176 deepseek_cmp vss 0.16065p
C177 oxa_ota vss 0.16065p
C178 gpt_ota vss 0.16065p
C179 deepseek_ota vss 0.16065p
C180 ibias vss 0.16065p
C181 inp vss 0.16065p
C182 inn vss 0.16065p
C183 clk vss 0.16545p
C184 vdd vss 3.47711p
C185 a_453622_319179# vss 4.43619f $ **FLOATING
C186 a_448866_319178# vss 3.64413f $ **FLOATING
C187 a_446174_319178# vss 2.83985f $ **FLOATING
C188 a_454802_322196# vss 1.96604f $ **FLOATING
C189 temp_sensor_0.TEMP_OUT vss 32.0811f $ **FLOATING
C190 a_451730_316152# vss 10.3876f $ **FLOATING
C191 a_451058_322196# vss 32.0867f $ **FLOATING
C192 a_444522_318971# vss 11.8841f $ **FLOATING
C193 a_446514_321988# vss 5.3867f $ **FLOATING
C194 a_445142_322198# vss 6.34937f $ **FLOATING
C195 a_450261_333180# vss 6.13782f $ **FLOATING
C196 io_secondary_3p3_4.ASIG5V vss 40.7433f $ **FLOATING
C197 a_449574_352580# vss 5.91326f $ **FLOATING
C198 vref_1v2$1_0.VREF vss 37.0605f $ **FLOATING
C199 io_secondary_3p3_2.ASIG5V vss 30.2735f $ **FLOATING
C200 a_449590_375410# vss 3.16287f $ **FLOATING
C201 a_449020_392562# vss 6.22471f $ **FLOATING
C202 io_secondary_3p3_3.ASIG5V vss 29.8638f $ **FLOATING
C203 strongarm_comparator$2_0.OUTN vss 2.98364f $ **FLOATING
C204 a_449030_395380# vss 3.33479f $ **FLOATING
C205 a_447858_395380# vss 2.87736f $ **FLOATING
C206 a_447160_411233# vss 5.75695f $ **FLOATING
C207 strongarm_comparator$3_0.OUTP vss 32.4642f $ **FLOATING
C208 strongarm_comparator$3_0.OUTN vss 7.02216f $ **FLOATING
C209 a_447764_415153# vss 4.90949f $ **FLOATING
C210 a_446108_415153# vss 4.15838f $ **FLOATING
C211 a_450384_431778# vss 6.06492f $ **FLOATING
C212 a_448488_431778# vss 3.73155f $ **FLOATING
C213 a_446992_431778# vss 3.98919f $ **FLOATING
C214 strongarm_comparator_0.OUTN vss 3.94113f $ **FLOATING
C215 io_secondary_3p3_8.ASIG5V vss 32.4516f $ **FLOATING
C216 a_450032_449122# vss 6.43921f $ **FLOATING
C217 ota$2_0.OUT vss 28.644f $ **FLOATING
C218 a_446966_452332# vss 3.49428f $ **FLOATING
C219 a_449616_457872# vss 6.03541f $ **FLOATING
C220 io_secondary_3p3_10.ASIG5V vss 26.2957f $ **FLOATING
C221 a_449526_465503# vss 2.32174f $ **FLOATING
C222 a_449296_472055# vss 6.45097f $ **FLOATING
C223 ota_0.OUT vss 26.2774f $ **FLOATING
C224 a_449366_474266# vss 2.3545f $ **FLOATING
C225 vref_1v2$2_0.IBIAS vss 0.23244p $ **FLOATING
C226 strongarm_comparator$2_0.INP vss 0.16684p $ **FLOATING
C227 strongarm_comparator$2_0.INN vss 0.15963p $ **FLOATING
C228 strongarm_comparator$2_0.CLK vss 0.14674p $ **FLOATING
.ends
