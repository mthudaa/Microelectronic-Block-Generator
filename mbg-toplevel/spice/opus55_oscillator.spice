* Self-starting 9-stage CMOS ring oscillator, gf180mcuD 3.3V
* Ports: VDD VSS OSC_OUT. Self-start via stage-1 PMOS asymmetry.
.subckt opus55_oscillator VDD VSS OSC_OUT
XM1p n1 OSC_OUT VDD VDD pfet_03v3 L=2.2u W=3.8u nf=1
XM1n n1 OSC_OUT VSS VSS nfet_03v3 L=2.2u W=2u nf=1
XM2p n2 n1 VDD VDD pfet_03v3 L=2.2u W=4u nf=1
XM2n n2 n1 VSS VSS nfet_03v3 L=2.2u W=2u nf=1
XM3p n3 n2 VDD VDD pfet_03v3 L=2.2u W=4u nf=1
XM3n n3 n2 VSS VSS nfet_03v3 L=2.2u W=2u nf=1
XM4p n4 n3 VDD VDD pfet_03v3 L=2.2u W=4u nf=1
XM4n n4 n3 VSS VSS nfet_03v3 L=2.2u W=2u nf=1
XM5p n5 n4 VDD VDD pfet_03v3 L=2.2u W=4u nf=1
XM5n n5 n4 VSS VSS nfet_03v3 L=2.2u W=2u nf=1
XM6p n6 n5 VDD VDD pfet_03v3 L=2.2u W=4u nf=1
XM6n n6 n5 VSS VSS nfet_03v3 L=2.2u W=2u nf=1
XM7p n7 n6 VDD VDD pfet_03v3 L=2.2u W=4u nf=1
XM7n n7 n6 VSS VSS nfet_03v3 L=2.2u W=2u nf=1
XM8p n8 n7 VDD VDD pfet_03v3 L=2.2u W=4u nf=1
XM8n n8 n7 VSS VSS nfet_03v3 L=2.2u W=2u nf=1
XM9p OSC_OUT n8 VDD VDD pfet_03v3 L=2.2u W=4u nf=1
XM9n OSC_OUT n8 VSS VSS nfet_03v3 L=2.2u W=2u nf=1
.ends opus55_oscillator
