.subckt opus55_strongarm_comparator VDD VSS INP INN CLK OUTP OUTN
XMTAIL SN CLK VSS VSS nfet_03v3 L=0.5u W=9.1u nf=1
XMINN SN_P INN SN VSS nfet_03v3 L=0.7u W=3u nf=1
XMINP SN_N INP SN VSS nfet_03v3 L=0.7u W=3u nf=1
XMLATN OUTN OUTP SN_N VSS nfet_03v3 L=0.5u W=2.3u nf=1
XMLATP OUTP OUTN SN_P VSS nfet_03v3 L=0.5u W=2.3u nf=1
XMPLTN OUTN OUTP VDD VDD pfet_03v3 L=0.5u W=3u nf=1
XMPLTP OUTP OUTN VDD VDD pfet_03v3 L=0.5u W=3u nf=1
XMPRSN SN_N CLK VDD VDD pfet_03v3 L=0.5u W=0.8u nf=1
XMPRSP SN_P CLK VDD VDD pfet_03v3 L=0.5u W=0.8u nf=1
XMPRON OUTN CLK VDD VDD pfet_03v3 L=0.5u W=1.6u nf=1
XMPROP OUTP CLK VDD VDD pfet_03v3 L=0.5u W=1.6u nf=1
.ends opus55_strongarm_comparator
