* PEX produced on Thu Jul 30 01:31:08 PM CST 2026 using /home/huda/opensource-project/Microelectronic-Block-Generator/designs/notebooks/chipathon2026-D/scripts/iic-pex.sh with m=2 and s=1
* NGSPICE file created from strongarm.ext - technology: gf180mcuD

.option scale=5n

.subckt strongarm vdd vss outp outn inp inn clk
X0 a_2430_1719# clk vdd vdd pfet_03v3 ad=48n pd=1.04m as=48n ps=1.04m w=400 l=200
X1 a_2430_1719# inp a_6725_n281# vss nfet_03v3 ad=48n pd=1.04m as=48n ps=1.04m w=400 l=200
X2 a_2430_1719# clk vdd vdd pfet_03v3 ad=48n pd=1.04m as=48n ps=1.04m w=400 l=200
X3 a_6725_n281# clk vss vss nfet_03v3 ad=48n pd=1.04m as=48n ps=1.04m w=400 l=200
X4 outp clk vdd vdd pfet_03v3 ad=48n pd=1.04m as=48n ps=1.04m w=400 l=200
X5 a_2430_1719# inn a_6725_n281# vss nfet_03v3 ad=48n pd=1.04m as=48n ps=1.04m w=400 l=200
X6 outn clk vdd vdd pfet_03v3 ad=48n pd=1.04m as=48n ps=1.04m w=400 l=200
X7 outn outp vdd vdd pfet_03v3 ad=48n pd=1.04m as=48n ps=1.04m w=400 l=200
X8 outp outn vdd vdd pfet_03v3 ad=48n pd=1.04m as=48n ps=1.04m w=400 l=200
X9 outp outn a_2430_1719# vss nfet_03v3 ad=48n pd=1.04m as=48n ps=1.04m w=400 l=200
X10 outn outp a_2430_1719# vss nfet_03v3 ad=48n pd=1.04m as=48n ps=1.04m w=400 l=200
C0 outn vdd 4.57653f
C1 a_2430_1719# vdd 3.56997f
C2 outn clk 0.41062f
C3 a_2430_1719# inn 0.0824f
C4 inn a_6725_n281# 0.11295f
C5 a_2430_1719# clk 0.81902f
C6 clk a_6725_n281# 0.13977f
C7 vdd outp 4.96737f
C8 a_2430_1719# inp 0.07099f
C9 inp a_6725_n281# 0.10263f
C10 outp clk 0.47077f
C11 a_2430_1719# outn 1.36874f
C12 a_2430_1719# a_6725_n281# 2.06496f
C13 outn outp 1.92594f
C14 a_2430_1719# outp 1.55884f
C15 vdd clk 4.40171f
C16 inp vss 0.66706f
C17 inn vss 0.66438f
C18 clk vss 3.34544f
C19 outn vss 4.00264f
C20 outp vss 4.98455f
C21 vdd vss 36.8134f
C22 a_6725_n281# vss 4.65685f ; **FLOATING
C23 a_2430_1719# vss 8.31412f ; **FLOATING
.ends
