.lib "/home/huda/.volare/gf180mcuD/libs.tech/ngspice/sm141064.ngspice" typical
.subckt strongarm vdd vss clk inn inp outn outp
XM1 tail clk vss vss nfet_03v3 L=1u W=2u nf=1
XM2 d1 inn tail vss nfet_03v3 L=1u W=2u nf=1
XM3 d1 inp tail vss nfet_03v3 L=1u W=2u nf=1
XM4 outn outp d1 vss nfet_03v3 L=1u W=2u nf=1
XM5 outp outn d1 vss nfet_03v3 L=1u W=2u nf=1
XM6 outn outp vdd vdd pfet_03v3 L=1u W=2u nf=1
XM7 outp outn vdd vdd pfet_03v3 L=1u W=2u nf=1
XM8 outn clk vdd vdd pfet_03v3 L=1u W=2u nf=1
XM9 outp clk vdd vdd pfet_03v3 L=1u W=2u nf=1
XM10 d1 clk vdd vdd pfet_03v3 L=1u W=2u nf=1
XM11 d1 clk vdd vdd pfet_03v3 L=1u W=2u nf=1
.ends
