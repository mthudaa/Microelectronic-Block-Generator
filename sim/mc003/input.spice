.include '/home/huda/.volare/gf180mcuD/libs.tech/ngspice/design.ngspice'
.lib '/home/huda/.volare/gf180mcuD/libs.tech/ngspice/sm141064.ngspice' statistical
.param sw_stat_mismatch=1

.subckt inv a y vdd vss
XM1 y a vdd vdd pfet_03v3 L=0.28u W=2u nf=1
XM2 y a vss vss nfet_03v3 L=0.28u W=1u nf=1
.ends

Vsupply0 vdd 0 3.3
Vsupply1 vss 0 0.0
Vsrc0 a 0 PULSE(0 3.3 1n 0.1n 0.1n 5n 10n)
Xdut a y vdd vss inv

.control
set seed=4
op
print v(a)
print v(y)
print v(vdd)
print v(vss)
.endc
.end
