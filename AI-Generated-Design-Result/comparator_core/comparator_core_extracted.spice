* NGSPICE file created from comparator_core.ext - technology: gf180mcuD

.subckt comparator_core vdd vss out vb inm inp
X0 a_3575_n881# vb vss vss nfet_03v3 ad=4.8p pd=17.2u as=4.8p ps=17.2u w=8u l=1u
X1 a_n100_14911# inm a_855_7119# vss nfet_03v3 ad=4.8p pd=17.2u as=4.8p ps=17.2u w=8u l=1u
X2 out a_1275_n489# vss vss nfet_03v3 ad=1.2p pd=5.2u as=1.2p ps=5.2u w=2u l=0.5u
X3 out a_1275_n489# vdd vdd pfet_03v3 ad=2.4p pd=9.2u as=2.4p ps=9.2u w=4u l=0.5u
X4 a_1275_n489# a_n100_14911# vdd vdd pfet_03v3 ad=4.8p pd=17.2u as=4.8p ps=17.2u w=8u l=1u
X5 a_1275_n489# inp a_855_7119# vss nfet_03v3 ad=4.8p pd=17.2u as=4.8p ps=17.2u w=8u l=1u
X6 a_n100_14911# a_n100_14911# vdd vdd pfet_03v3 ad=4.8p pd=17.2u as=4.8p ps=17.2u w=8u l=1u
.ends
