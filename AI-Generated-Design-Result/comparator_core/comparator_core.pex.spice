* SPICE3 file created from comparator_core.ext - technology: gf180mcuD

.option scale=5n

.subckt comparator_core vdd vss out vb inm inp
X0 a_855_7119# vb vss vss nfet_03v3 ad=0.192u pd=3.44m as=0.192u ps=3.44m w=1600 l=200
X1 a_n100_14911# inm a_855_7119# vss nfet_03v3 ad=0.192u pd=3.44m as=0.192u ps=3.44m w=1600 l=200
X2 out a_1275_n489# vss vss nfet_03v3 ad=48n pd=1.04m as=48n ps=1.04m w=400 l=100
X3 out a_1275_n489# vdd vdd pfet_03v3 ad=96n pd=1.84m as=96n ps=1.84m w=800 l=100
X4 a_1275_n489# a_n100_14911# vdd vdd pfet_03v3 ad=0.192u pd=3.44m as=0.192u ps=3.44m w=1600 l=200
X5 a_1275_n489# inp a_855_7119# vss nfet_03v3 ad=0.192u pd=3.44m as=0.192u ps=3.44m w=1600 l=200
X6 a_n100_14911# a_n100_14911# vdd vdd pfet_03v3 ad=0.192u pd=3.44m as=0.192u ps=3.44m w=1600 l=200
C0 a_1275_n489# a_855_7119# 2.05011f
C1 inp a_1275_n489# 0.26096f
C2 vdd a_n100_14911# 4.71504f
C3 a_1275_n489# inm 0.03213f
C4 a_1275_n489# out 1.04762f
C5 a_855_7119# a_n100_14911# 0.9405f
C6 vb a_855_7119# 0.26096f
C7 inm a_n100_14911# 0.26096f
C8 inp a_855_7119# 0.30594f
C9 out vdd 2.49835f
C10 out a_n100_14911# 0.04848f
C11 a_855_7119# inm 0.28735f
C12 a_1275_n489# vdd 3.45619f
C13 a_1275_n489# a_n100_14911# 0.40731f
C14 a_855_7119# out 0.10214f
C15 out vss 11.47898f
C16 vdd vss 29.74067f
* C17 m4_3681_4884# vss 0.04598f
*C18 a_3575_n881# vss 3.04829f
C18 a_855_7119# vss 3.04829f
C19 a_855_7119# vss 3.55645f
C20 a_1275_n489# vss 2.98754f
.ends
