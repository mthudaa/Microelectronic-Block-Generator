*=============================================================================
*  Two-Stage Open-Loop Comparator
*  Technology: GF180MCU 3.3V
*  Specs: Gain >= 40dB, Delay < 200ns, Power < 200uA, Offset < 20mV
*  Topology: NMOS-input diff pair + PMOS current mirror + CMOS inverter output
*=============================================================================

.subckt comparator_core vdd vss inp inm vb out
* Stage 1: Differential pair with current mirror load
* NMOS input pair is MMD (multi-finger matched devices)
XM1 n1 inm tail vss nfet_03v3 L=1u W=8u nf=2
XM2 n2 inp tail vss nfet_03v3 L=1u W=8u nf=2
* PMOS current mirror load
XM3 n1 n1 vdd vdd pfet_03v3 L=1u W=8u nf=2
XM4 n2 n1 vdd vdd pfet_03v3 L=1u W=8u nf=2
* Tail current source (NMOS)
XM5 tail vb vss vss nfet_03v3 L=1u W=8u nf=2
* Stage 2: CMOS inverter for rail-to-rail output
XM6 out n2 vdd vdd pfet_03v3 L=0.5u W=4u nf=1
XM7 out n2 vss vss nfet_03v3 L=0.5u W=2u nf=1
.ends
