* NGSPICE file created from comparator_core.ext - technology: gf180mcuD

.subckt comparator_core vdd inp inm vb out
X0 vss vb a_699_7119# vss nfet_03v3 ad=4.8p pd=17.2u as=2.24p ps=8.56u w=8u l=1u
X1 a_n256_14911# inm a_699_7119# vss nfet_03v3 ad=2.24p pd=8.56u as=4.8p ps=17.2u w=8u l=1u
X2 out a_1540_n489# vdd vdd pfet_03v3 ad=2.4p pd=9.2u as=2.4p ps=9.2u w=4u l=0.5u
X3 a_n256_14911# a_n256_14911# vdd vdd pfet_03v3 ad=2.24p pd=8.56u as=4.8p ps=17.2u w=8u l=1u
X4 vdd a_n256_14911# a_1540_n489# vdd pfet_03v3 ad=4.8p pd=17.2u as=2.24p ps=8.56u w=8u l=1u
X5 a_699_7119# vb vss vss nfet_03v3 ad=2.24p pd=8.56u as=4.8p ps=17.2u w=8u l=1u
X6 a_699_7119# inp a_1540_n489# vss nfet_03v3 ad=4.8p pd=17.2u as=2.24p ps=8.56u w=8u l=1u
X7 out a_1540_n489# vss vss nfet_03v3 ad=1.2p pd=5.2u as=1.2p ps=5.2u w=2u l=0.5u
X8 vdd a_n256_14911# a_n256_14911# vdd pfet_03v3 ad=4.8p pd=17.2u as=2.24p ps=8.56u w=8u l=1u
X9 a_1540_n489# a_n256_14911# vdd vdd pfet_03v3 ad=2.24p pd=8.56u as=4.8p ps=17.2u w=8u l=1u
X10 a_699_7119# inm a_n256_14911# vss nfet_03v3 ad=4.8p pd=17.2u as=2.24p ps=8.56u w=8u l=1u
X11 a_1540_n489# inp a_699_7119# vss nfet_03v3 ad=2.24p pd=8.56u as=4.8p ps=17.2u w=8u l=1u
.ends
