* NGSPICE file created from ota_5t.ext - technology: gf180mcuD

.subckt ota_5t vb out inm inp vss vdd
X0 out inm a_n1742_2849# vss nfet_03v3 ad=0.28p pd=1.56u as=0.6p ps=3.2u w=1u l=1u
X1 out a_n1622_5061# vdd vdd pfet_03v3 ad=0.28p pd=1.56u as=0.28p ps=1.56u w=1u l=1u
X2 vss vb a_n1742_2849# vss nfet_03v3 ad=0.6p pd=3.2u as=0.28p ps=1.56u w=1u l=1u
X3 a_n1622_5061# inp a_n1742_2849# vss nfet_03v3 ad=0.28p pd=1.56u as=0.6p ps=3.2u w=1u l=1u
X4 a_n1622_5061# inp a_n1742_2849# vss nfet_03v3 ad=0.28p pd=1.56u as=0.28p ps=1.56u w=1u l=1u
X5 out a_n1622_5061# vdd vdd pfet_03v3 ad=0.28p pd=1.56u as=0.6p ps=3.2u w=1u l=1u
X6 vss vb a_n1742_2849# vss nfet_03v3 ad=0.28p pd=1.56u as=0.28p ps=1.56u w=1u l=1u
X7 a_n1742_2849# vb vss vss nfet_03v3 ad=0.28p pd=1.56u as=0.28p ps=1.56u w=1u l=1u
X8 a_n1622_5061# a_n1622_5061# vdd vdd pfet_03v3 ad=0.28p pd=1.56u as=0.6p ps=3.2u w=1u l=1u
X9 a_n1622_5061# a_n1622_5061# vdd vdd pfet_03v3 ad=0.28p pd=1.56u as=0.28p ps=1.56u w=1u l=1u
X10 a_n1742_2849# inm out vss nfet_03v3 ad=0.6p pd=3.2u as=0.28p ps=1.56u w=1u l=1u
X11 a_n1742_2849# vb vss vss nfet_03v3 ad=0.28p pd=1.56u as=0.6p ps=3.2u w=1u l=1u
X12 a_n1742_2849# inp a_n1622_5061# vss nfet_03v3 ad=0.28p pd=1.56u as=0.28p ps=1.56u w=1u l=1u
X13 a_n1742_2849# inm out vss nfet_03v3 ad=0.28p pd=1.56u as=0.28p ps=1.56u w=1u l=1u
X14 vdd a_n1622_5061# out vdd pfet_03v3 ad=0.6p pd=3.2u as=0.28p ps=1.56u w=1u l=1u
X15 vdd a_n1622_5061# a_n1622_5061# vdd pfet_03v3 ad=0.28p pd=1.56u as=0.28p ps=1.56u w=1u l=1u
X16 vdd a_n1622_5061# out vdd pfet_03v3 ad=0.28p pd=1.56u as=0.28p ps=1.56u w=1u l=1u
X17 a_n1742_2849# inp a_n1622_5061# vss nfet_03v3 ad=0.6p pd=3.2u as=0.28p ps=1.56u w=1u l=1u
X18 vdd a_n1622_5061# a_n1622_5061# vdd pfet_03v3 ad=0.6p pd=3.2u as=0.28p ps=1.56u w=1u l=1u
X19 out inm a_n1742_2849# vss nfet_03v3 ad=0.28p pd=1.56u as=0.28p ps=1.56u w=1u l=1u
.ends
