*==============================================================================
* Two-Stage Open-Loop Comparator   —   GF180MCU 3.3V PDK   (SIMPLIFIED sizing)
* All PMOS use nf=2 to ease layout/DRC routing of auto-router.
*
* Targets:  |Av| >= 40 dB, Delay < 200 ns, Idd < 200 uA, |Vos| < 20 mV
* Topology:
*   M1,M2 NMOS diff pair + M3,M4 PMOS mirror load + M5 NMOS tail (mirror of M8)
*   Stage2: M6 NMOS driver, M7 PMOS active load (gate = M3's gate = int_p)
*   M8 diode reference fed by external ibias current.
*==============================================================================
.include "/home/huda/.volare/gf180mcuD/libs.tech/ngspice/design.ngspice"
.lib "/home/huda/.volare/gf180mcuD/libs.tech/ngspice/sm141064.ngspice" typical
.lib "/home/huda/.volare/gf180mcuD/libs.tech/ngspice/sm141064.ngspice" diode_typical

.subckt two_stage_comparator vdd vss inp inm out ibias
XM8   ibias  ibias vss vss nfet_03v3  L=1u W=3u nf=2 m=1
XM3   int_p  int_p vdd vdd  pfet_03v3  L=1u W=4u nf=2 m=1
XM4   int_n  int_p vdd vdd  pfet_03v3  L=1u W=4u nf=2 m=1
XM1   int_p    inp int_src vss nfet_03v3  L=1u W=3u nf=2 m=1
XM2   int_n    inm int_src vss nfet_03v3  L=1u W=3u nf=2 m=1
XM5   int_src ibias vss vss  nfet_03v3  L=1u W=3u nf=2 m=1
XM7   out    int_p vdd vdd  pfet_03v3  L=1u W=4u nf=2 m=1
XM6   out    int_n vss vss  nfet_03v3  L=1u W=3u nf=2 m=1
.ends

*==============================================================================
* Testbench
*==============================================================================
X1  vdd 0  inp inm out  ibias_node  two_stage_comparator

VDD  vdd 0  3.3
Ibias_src  0 ibias_node 40u

Vin_p  inp 0  dc 1.65 ac 1  pulse(1.575 1.725 50n 1n 1n 100n 200n)
Vin_m  inm 0  dc 1.65

CL out 0 1p

.control
save all

* ---------------- DC OP ----------------
op
echo ==================== DC OP POINT (default pulse baseline) ====================
print v(inp) v(inm) v(int_p) v(int_n) v(out) v(int_src)
echo "Supply current via VDD branch (A):"
print i(VDD)

* ---------------- DC transfer ----------------
dc Vin_p 1.60 1.70 0.5m
let dVout_dx = deriv(v(out))
let Av_dc_lin = maximum(abs(dVout_dx))
let Av_dc_db  = 20*log10(Av_dc_lin)
print Av_dc_lin Av_dc_db
meas dc v_in_trip FIND v(inp) WHEN v(out)=1.65
let Vos_nominal = v_in_trip - 1.65
print Vos_nominal
meas dc v_in_low   FIND v(inp) WHEN v(out)=0.33
meas dc v_in_high  FIND v(inp) WHEN v(out)=2.97
write comparator_pre_dc.raw all

* ---------------- AC re-bias at trip ----------------
let v_trip_val = v_in_trip
alter Vin_p dc v_trip_val
op
echo ==================== DC OP POINT (post-alter, at trip) ====================
print v(inp) v(inm) v(int_p) v(int_n) v(out) v(int_src)

ac dec 20 1 1G
let vgain_db = 20*log10(v(out)/v(inp))
print vgain_db[0] vgain_db[100]
meas ac Av_ac_db_at100  FIND vgain_db AT=100
meas ac GBW             when vgain_db=0 fall=1
write comparator_pre_ac.raw all

* ---------------- TRAN ----------------
alter Vin_p dc 1.65
op
tran 0.5n 250n
meas tran t_in_cross   WHEN v(inp)=1.65 RISE=1
meas tran t_out_cross  WHEN v(out)=1.65 FALL=1
let t_delay = abs(t_out_cross - t_in_cross)
print t_delay
meas tran Idd_avg_tr   AVG i(VDD) FROM=0 TO=250n
print Idd_avg_tr
write comparator_pre_tran.raw all
.endc
.END
