* PEX produced on Thu Aug 13 05:38:16 AM CST 2026 using /home/huda/.pi/scripts/iic-pex.sh with m=2 and s=1
* NGSPICE file created from two_stage_comparator.ext - technology: gf180mcuD

.option scale=5n

.subckt two_stage_comparator vdd vss ibias out inm inp
X0 vdd a_n256_5311# a_3124_5519# vdd pfet_03v3 ad=96n pd=1.84m as=44.8n ps=0.912m w=800 l=200
X1 a_3124_5519# inm a_1214_2619# vss nfet_03v3 ad=33.6n pd=0.712m as=72n ps=1.44m w=600 l=200
X2 out a_3124_5519# vss vss nfet_03v3 ad=33.6n pd=0.712m as=72n ps=1.44m w=600 l=200
X3 vdd a_n256_5311# a_n256_5311# vdd pfet_03v3 ad=96n pd=1.84m as=44.8n ps=0.912m w=800 l=200
X4 a_n256_5311# a_n256_5311# vdd vdd pfet_03v3 ad=44.8n pd=0.912m as=96n ps=1.84m w=800 l=200
X5 a_3124_5519# a_n256_5311# vdd vdd pfet_03v3 ad=44.8n pd=0.912m as=96n ps=1.84m w=800 l=200
X6 a_n256_5311# inp a_1214_2619# vss nfet_03v3 ad=33.6n pd=0.712m as=72n ps=1.44m w=600 l=200
X7 out a_n256_5311# vdd vdd pfet_03v3 ad=44.8n pd=0.912m as=96n ps=1.84m w=800 l=200
X8 a_1214_2619# inm a_3124_5519# vss nfet_03v3 ad=72n pd=1.44m as=33.6n ps=0.712m w=600 l=200
X9 vss a_3124_5519# out vss nfet_03v3 ad=72n pd=1.44m as=33.6n ps=0.712m w=600 l=200
X10 a_1214_2619# inp a_n256_5311# vss nfet_03v3 ad=72n pd=1.44m as=33.6n ps=0.712m w=600 l=200
X11 vss ibias a_1214_2619# vss nfet_03v3 ad=72n pd=1.44m as=33.6n ps=0.712m w=600 l=200
X12 vdd a_n256_5311# out vdd pfet_03v3 ad=96n pd=1.84m as=44.8n ps=0.912m w=800 l=200
X13 ibias ibias vss vss nfet_03v3 ad=33.6n pd=0.712m as=72n ps=1.44m w=600 l=200
X14 vss ibias ibias vss nfet_03v3 ad=72n pd=1.44m as=33.6n ps=0.712m w=600 l=200
X15 a_1214_2619# ibias vss vss nfet_03v3 ad=33.6n pd=0.712m as=72n ps=1.44m w=600 l=200
C0 a_n256_5311# out 0.39254f
C1 a_1214_2619# inp 0.28856f
C2 out a_3124_5519# 0.5873f
C3 a_n256_5311# a_3124_5519# 0.44496f
C4 a_1214_2619# ibias 0.26257f
C5 out vdd 1.93232f
C6 a_n256_5311# vdd 7.51359f
C7 vdd a_3124_5519# 2.25614f
C8 a_n256_5311# a_1214_2619# 0.95642f
C9 a_1214_2619# a_3124_5519# 1.23546f
C10 inm a_3124_5519# 0.28322f
C11 a_n256_5311# inp 0.26208f
C12 a_1214_2619# inm 0.26857f
C13 ibias vss 6.27493f
C14 inm vss 1.26031f
C15 inp vss 1.3206f
C16 out vss 3.02263f
C17 vdd vss 28.3017f
C18 a_1214_2619# vss 6.10976f ; **FLOATING
C19 a_3124_5519# vss 4.81433f ; **FLOATING
C20 a_n256_5311# vss 3.15994f ; **FLOATING
.ends
