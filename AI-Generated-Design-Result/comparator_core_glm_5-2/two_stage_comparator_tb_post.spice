*==============================================================================
* Post-Layout Simulation of Two-Stage Open-Loop Comparator
* PEX-extracted from GF180MCU GDS via Magic (mode 2, C-coupled).
* Uses same testbench as pre-layout so measurements can be compared directly.
*==============================================================================
.include "/home/huda/.volare/gf180mcuD/libs.tech/ngspice/design.ngspice"
.lib "/home/huda/.volare/gf180mcuD/libs.tech/ngspice/sm141064.ngspice" typical
.lib "/home/huda/.volare/gf180mcuD/libs.tech/ngspice/sm141064.ngspice" diode_typical

* Include the PEX-extracted layout subckt.  Its port order is
* '.subckt two_stage_comparator vdd vss ibias out inm inp'.
.include "/home/huda/mbg_runs/comparator_simplified/two_stage_comparator/two_stage_comparator.pex.spice"

* Instantiate by NAME-PORT order; explicit use of pin names avoids confusion.
X1 vdd 0 ibias_node out inm inp two_stage_comparator

VDD vdd 0 3.3
Ibias_src 0 ibias_node 40u

Vin_p inp 0  dc 1.65 ac 1  pulse(1.575 1.725 50n 1n 1n 100n 200n)
Vin_m inm 0  dc 1.65
CL out 0 1p

.control
save all

* ---------------- DC OP ----------------
op
echo ==================== DC OP POINT (post-layout) ====================
print v(inp) v(inm) v(out) v(ibias_node)
echo "Supply current via VDD (A):"
print i(VDD)

* ---------------- DC transfer (gain) ----------------
dc Vin_p 1.60 1.70 0.5m
let dVout_dx = deriv(v(out))
let Av_dc_lin = maximum(abs(dVout_dx))
let Av_dc_db  = 20*log10(Av_dc_lin)
print Av_dc_lin Av_dc_db
meas dc v_in_trip FIND v(inp) WHEN v(out)=1.65
let Vos_nominal = v_in_trip - 1.65
print Vos_nominal
meas dc v_in_low   FIND v(inp) WHEN v(out)=0.33
meas dc v_in_high  FIND v(inp) WHEN v(out)=2.97
write comparator_post_dc.raw all

* ---------------- AC response re-biased at trip ----------------
alter Vin_p dc v_in_trip
op
print v(inp) v(inm) v(out)

ac dec 20 1 1G
let vgain_db = 20*log10(v(out)/v(inp))
print vgain_db[0] vgain_db[100]
meas ac Av_ac_db_at100  FIND vgain_db AT=100
meas ac GBW             when vgain_db=0 fall=1
write comparator_post_ac.raw all

* ---------------- TRAN step delay ----------------
alter Vin_p dc 1.65
tran 0.5n 250n
meas tran t_in_cross   WHEN v(inp)=1.65 RISE=1
meas tran t_out_cross  WHEN v(out)=1.65 FALL=1
let t_delay = abs(t_out_cross - t_in_cross)
print t_delay
meas tran Idd_avg_tr   AVG i(VDD) FROM=0 TO=250n
print Idd_avg_tr
write comparator_post_tran.raw all
.endc
.END
