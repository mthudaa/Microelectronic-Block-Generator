* DC Transfer Pre-Layout
.include '/home/huda/.volare/gf180mcuD/libs.tech/ngspice/design.ngspice'
.lib '/home/huda/.volare/gf180mcuD/libs.tech/ngspice/sm141064.ngspice' typical
.include ota_5t.spice

X1 vdd vss inp inm out vb ota_5t
Vdd vdd 0 DC 3.3
Vss vss 0 DC 0
Vb vb 0 DC 2.3
Vinp inp 0 DC 1.65
Vinm inm 0 DC 1.65

.control
dc Vinp 1.5 1.8 0.001
wrdata dc_pre.dat v(out) v(inp)
.endc
.END
