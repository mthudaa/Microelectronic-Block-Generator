* PMOS-input 5T-OTA Pre-Layout Testbench
.include '/home/huda/.volare/gf180mcuD/libs.tech/ngspice/design.ngspice'
.lib '/home/huda/.volare/gf180mcuD/libs.tech/ngspice/sm141064.ngspice' typical

.include ota_5t.spice

X1 vdd vss inp inm out vb ota_5t

Vdd vdd 0 DC 3.3
Vss vss 0 DC 0
Vb vb 0 DC 2.3

Vinp inp 0 DC 1.65 AC 1
Vinm inm 0 DC 1.65

CL out 0 1p

.control
op
ac dec 10 1 1e9
meas ac gain_db MAX vdb(out)
.endc

.END
