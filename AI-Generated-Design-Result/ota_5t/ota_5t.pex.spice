* SPICE3 file created from ota_5t.ext - technology: gf180mcuD

.option scale=5n

.subckt ota_5t vdd vss vb out inm inp
X0 a_n220_1519# vb vdd vdd pfet_03v3 ad=96n pd=1.84m as=96n ps=1.84m w=800 l=200
X1 a_100_1519# inp a_n220_1519# vdd pfet_03v3 ad=96n pd=1.84m as=96n ps=1.84m w=800 l=200
X2 out inm a_n220_1519# vdd pfet_03v3 ad=96n pd=1.84m as=96n ps=1.84m w=800 l=200
X3 out a_100_1519# vss vss nfet_03v3 ad=48n pd=1.04m as=48n ps=1.04m w=400 l=200
X4 a_100_1519# a_100_1519# vss vss nfet_03v3 ad=48n pd=1.04m as=48n ps=1.04m w=400 l=200
C0 inp a_100_1519# 0.14791f
C1 a_n220_1519# vb 0.13418f
C2 a_n220_1519# a_100_1519# 0.95985f
C3 vdd a_100_1519# 1.27424f
C4 vdd vb 0.76485f
C5 out a_n220_1519# 1.0055f
C6 out vdd 1.22784f
C7 out inm 0.14791f
C8 inp a_n220_1519# 0.16572f
C9 vdd inp 0.62203f
C10 vdd a_n220_1519# 3.84429f
C11 a_n220_1519# inm 0.16572f
C12 vdd inm 0.61749f
C13 out a_100_1519# 0.07175f
C14 out vss 5.03469f
C15 vdd vss 22.26805f
C16 a_n220_1519# vss 1.26232f
.ends
