* Slew Rate Transient
.include '/home/huda/.volare/gf180mcuD/libs.tech/ngspice/design.ngspice'
.lib '/home/huda/.volare/gf180mcuD/libs.tech/ngspice/sm141064.ngspice' typical
.include ota_5t.spice

X1 vdd vss inp inm out vb ota_5t
Vdd vdd 0 DC 3.3
Vss vss 0 DC 0
Vb vb 0 DC 2.3
Vinp inp 0 PULSE(1.15 2.15 50n 0.5n 0.5n 200n 500n)
Vinm inm 0 DC 1.65
CL out 0 1p

.control
tran 0.05n 500n
wrdata tran_pre.dat v(out) time
.endc
.END
