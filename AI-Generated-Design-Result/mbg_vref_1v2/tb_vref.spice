* Testbench for vref_1v2 beta-multiplier voltage reference
.include "/home/huda/.volare/gf180mcuD/libs.tech/ngspice/design.ngspice"
.lib "/home/huda/.volare/gf180mcuD/libs.tech/ngspice/sm141064.ngspice" typical
.include "vref_1v2.spice"

* Supply and instance
Vvdd vdd 0 DC 3.3
Vvss vss 0 DC 0
Xref vdd vss vref vref_1v2

* Load cap for stability
Cload vref 0 0.1p

.control
  set temp=27

  echo "=== 1. DC OPERATING POINT ==="
  op
  print v(vref)

  echo "=== 2. DC SWEEP: Vref vs VDD (0 to 3.3V) ==="
  dc Vvdd 0 3.3 0.005
  plot v(vref) vs v(vdd)
  write vref_dc.raw

  echo "=== 3. TEMPERATURE SWEEP (-40 to 125C) ==="
  alter Vvdd DC 3.3
  dc temp -40 125 1
  plot v(vref)
  write vref_temp.raw

  echo "=== 4. TRANSIENT POWER-UP ==="
  alter Vvdd DC 0 PULSE(0 3.3 1u 1u 1u 10u 20u)
  set temp=27
  tran 100n 20u
  plot v(vref) vs v(vdd)
  write vref_tran.raw

  echo "=== ALL SIMULATIONS COMPLETE ==="
.endc

.end
