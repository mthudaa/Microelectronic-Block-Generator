* MOSFET-only Beta-Multiplier Voltage Reference
* Target: Vref = 1.2V @ VDD=3.3V, GF180MCU 3.3V
* Relaxed tempco (>200 ppm/C)
* Model libraries are included by the testbench — do NOT re-include here.

.subckt vref_1v2 vdd vss vref
* PMOS current mirror (1:1:1)
XM3 d1 d1 vdd vdd pfet_03v3 L=2u W=4u nf=2
XM4 d2 d1 vdd vdd pfet_03v3 L=2u W=4u nf=2
XM5 vref d1 vdd vdd pfet_03v3 L=2u W=4u nf=2

* Beta-multiplier NMOS pair (K:1 = 2:1 via nf=2 vs nf=1)
XM1 d1 d1 vss vss nfet_03v3 L=2u W=4u nf=2
XM2 d2 d1 src2 vss nfet_03v3 L=2u W=4u nf=1

* Triode NMOS resistor (gate=VDD, deep triode degenerating element)
XM_r src2 vdd vss vss nfet_03v3 L=2u W=4u nf=1

* Output diode-connected NMOS load
XM6 vref vref vss vss nfet_03v3 L=2u W=4u nf=1

.ends
