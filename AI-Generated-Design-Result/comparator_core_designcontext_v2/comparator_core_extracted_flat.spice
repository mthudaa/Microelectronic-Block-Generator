* NGSPICE file created from comparator_core.ext - technology: gf180mcuD

.subckt comparator_core vdd vss inp inm vb out
X0 vdd a_n1734_6256# a_n50_6464# vdd pfet_03v3 ad=2.4p pd=9.2u as=1.12p ps=4.56u w=4u l=1u
X1 a_n50_6464# inp a_n1118_3446# vss nfet_03v3 ad=1.12p pd=4.56u as=2.4p ps=9.2u w=4u l=1u
X2 a_n1734_6256# inm a_n1118_3446# vss nfet_03v3 ad=1.12p pd=4.56u as=2.4p ps=9.2u w=4u l=1u
X3 vdd a_n1734_6256# a_n1734_6256# vdd pfet_03v3 ad=2.4p pd=9.2u as=1.12p ps=4.56u w=4u l=1u
X4 out a_n50_6464# vss vss nfet_03v3 ad=1.2p pd=5.2u as=1.2p ps=5.2u w=2u l=0.5u
X5 a_n50_6464# a_n1734_6256# vdd vdd pfet_03v3 ad=1.12p pd=4.56u as=2.4p ps=9.2u w=4u l=1u
X6 a_n1118_3446# inp a_n50_6464# vss nfet_03v3 ad=2.4p pd=9.2u as=1.12p ps=4.56u w=4u l=1u
X7 vss vb a_n1118_3446# vss nfet_03v3 ad=2.4p pd=9.2u as=1.12p ps=4.56u w=4u l=1u
X8 a_n1118_3446# inm a_n1734_6256# vss nfet_03v3 ad=2.4p pd=9.2u as=1.12p ps=4.56u w=4u l=1u
X9 a_n1734_6256# a_n1734_6256# vdd vdd pfet_03v3 ad=1.12p pd=4.56u as=2.4p ps=9.2u w=4u l=1u
X10 out a_n50_6464# vdd vdd pfet_03v3 ad=2.4p pd=9.2u as=2.4p ps=9.2u w=4u l=0.5u
X11 a_n1118_3446# vb vss vss nfet_03v3 ad=1.12p pd=4.56u as=2.4p ps=9.2u w=4u l=1u
.ends
