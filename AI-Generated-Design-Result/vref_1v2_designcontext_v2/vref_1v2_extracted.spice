* NGSPICE file created from vref_1v2.ext - technology: gf180mcuD

.subckt vref_1v2 vref vss vdd
X0 a_n1347_6256# a_n1347_6256# vss vss nfet_03v3 ad=2.4p pd=9.2u as=2.4p ps=9.2u w=4u l=1.25u
X1 a_125_6464# a_n1347_6256# a_n661_428# vss nfet_03v3 ad=2.4p pd=9.2u as=2.4p ps=9.2u w=4u l=1.25u
X2 vref vref vss vss nfet_03v3 ad=2.4p pd=9.2u as=2.4p ps=9.2u w=4u l=1u
X3 a_125_6464# a_n1347_6256# vdd vdd pfet_03v3 ad=2.4p pd=9.2u as=2.4p ps=9.2u w=4u l=1.25u
X4 vref a_n1347_6256# vdd vdd pfet_03v3 ad=2.4p pd=9.2u as=2.4p ps=9.2u w=4u l=1.25u
X5 a_n1347_6256# a_n1347_6256# vdd vdd pfet_03v3 ad=2.4p pd=9.2u as=2.4p ps=9.2u w=4u l=1.25u
X6 a_n661_428# vdd vss vss nfet_03v3 ad=2.4p pd=9.2u as=2.4p ps=9.2u w=4u l=1.25u
.ends
