* SPICE3 file created from ota_5t.ext - technology: gf180mcuD

.option scale=5n

.subckt ota_5t vdd vss vb out inm inp
X0 out inm a_n688_3519# vss nfet_03v3 ad=44.8n pd=0.912m as=96n ps=1.84m w=800 l=200
X1 vdd a_n568_7311# a_n568_7311# vdd pfet_03v3 ad=96n pd=1.84m as=44.8n ps=0.912m w=800 l=200
X2 vss vb a_n688_3519# vss nfet_03v3 ad=96n pd=1.84m as=44.8n ps=0.912m w=800 l=200
X3 a_n688_3519# inp a_n568_7311# vss nfet_03v3 ad=96n pd=1.84m as=44.8n ps=0.912m w=800 l=200
X4 out a_n568_7311# vdd vdd pfet_03v3 ad=44.8n pd=0.912m as=44.8n ps=0.912m w=800 l=200
X5 a_n568_7311# a_n568_7311# vdd vdd pfet_03v3 ad=44.8n pd=0.912m as=44.8n ps=0.912m w=800 l=200
X6 vdd a_n568_7311# a_n568_7311# vdd pfet_03v3 ad=44.8n pd=0.912m as=44.8n ps=0.912m w=800 l=200
X7 out inm a_n688_3519# vss nfet_03v3 ad=44.8n pd=0.912m as=44.8n ps=0.912m w=800 l=200
X8 vdd a_n568_7311# out vdd pfet_03v3 ad=44.8n pd=0.912m as=44.8n ps=0.912m w=800 l=200
X9 vdd a_n568_7311# out vdd pfet_03v3 ad=96n pd=1.84m as=44.8n ps=0.912m w=800 l=200
X10 a_n688_3519# inp a_n568_7311# vss nfet_03v3 ad=44.8n pd=0.912m as=44.8n ps=0.912m w=800 l=200
X11 a_n568_7311# inp a_n688_3519# vss nfet_03v3 ad=44.8n pd=0.912m as=44.8n ps=0.912m w=800 l=200
X12 a_n688_3519# vb vss vss nfet_03v3 ad=44.8n pd=0.912m as=96n ps=1.84m w=800 l=200
X13 a_n688_3519# inm out vss nfet_03v3 ad=44.8n pd=0.912m as=44.8n ps=0.912m w=800 l=200
X14 a_n688_3519# inm out vss nfet_03v3 ad=96n pd=1.84m as=44.8n ps=0.912m w=800 l=200
X15 a_n688_3519# vb vss vss nfet_03v3 ad=44.8n pd=0.912m as=44.8n ps=0.912m w=800 l=200
X16 a_n568_7311# a_n568_7311# vdd vdd pfet_03v3 ad=44.8n pd=0.912m as=96n ps=1.84m w=800 l=200
X17 a_n568_7311# inp a_n688_3519# vss nfet_03v3 ad=44.8n pd=0.912m as=96n ps=1.84m w=800 l=200
X18 vss vb a_n688_3519# vss nfet_03v3 ad=44.8n pd=0.912m as=44.8n ps=0.912m w=800 l=200
X19 out a_n568_7311# vdd vdd pfet_03v3 ad=44.8n pd=0.912m as=96n ps=1.84m w=800 l=200
C0 a_n688_3519# inm 0.72189f
C1 a_n568_7311# out 0.74344f
C2 a_n688_3519# inp 0.76176f
C3 a_n688_3519# a_n568_7311# 2.16643f
C4 inm out 0.65236f
C5 a_n688_3519# out 2.16031f
C6 a_n568_7311# inp 0.65219f
C7 a_n568_7311# vdd 10.4756f
C8 a_n688_3519# vb 0.65166f
C9 vdd out 3.45867f
C10 out vss 4.10734f
C11 vdd vss 28.76965f
C12 a_n688_3519# vss 13.29417f
.ends
