* NGSPICE file created from ota_5t.ext - technology: gf180mcuD

.subckt ota_5t vdd vss inp inm out vb
X0 out inm a_n688_3519# vss nfet_03v3 ad=1.12p pd=4.56u as=2.4p ps=9.2u w=4u l=1u
X1 vdd a_n568_7311# a_n568_7311# vdd pfet_03v3 ad=2.4p pd=9.2u as=1.12p ps=4.56u w=4u l=1u
X2 vss vb a_n688_3519# vss nfet_03v3 ad=2.4p pd=9.2u as=1.12p ps=4.56u w=4u l=1u
X3 a_n688_3519# inp a_n568_7311# vss nfet_03v3 ad=2.4p pd=9.2u as=1.12p ps=4.56u w=4u l=1u
X4 out a_n568_7311# vdd vdd pfet_03v3 ad=1.12p pd=4.56u as=1.12p ps=4.56u w=4u l=1u
X5 a_n568_7311# a_n568_7311# vdd vdd pfet_03v3 ad=1.12p pd=4.56u as=1.12p ps=4.56u w=4u l=1u
X6 vdd a_n568_7311# a_n568_7311# vdd pfet_03v3 ad=1.12p pd=4.56u as=1.12p ps=4.56u w=4u l=1u
X7 out inm a_n688_3519# vss nfet_03v3 ad=1.12p pd=4.56u as=1.12p ps=4.56u w=4u l=1u
X8 vdd a_n568_7311# out vdd pfet_03v3 ad=1.12p pd=4.56u as=1.12p ps=4.56u w=4u l=1u
X9 vdd a_n568_7311# out vdd pfet_03v3 ad=2.4p pd=9.2u as=1.12p ps=4.56u w=4u l=1u
X10 a_n688_3519# inp a_n568_7311# vss nfet_03v3 ad=1.12p pd=4.56u as=1.12p ps=4.56u w=4u l=1u
X11 a_n568_7311# inp a_n688_3519# vss nfet_03v3 ad=1.12p pd=4.56u as=1.12p ps=4.56u w=4u l=1u
X12 a_n688_3519# vb vss vss nfet_03v3 ad=1.12p pd=4.56u as=2.4p ps=9.2u w=4u l=1u
X13 a_n688_3519# inm out vss nfet_03v3 ad=1.12p pd=4.56u as=1.12p ps=4.56u w=4u l=1u
X14 a_n688_3519# inm out vss nfet_03v3 ad=2.4p pd=9.2u as=1.12p ps=4.56u w=4u l=1u
X15 a_n688_3519# vb vss vss nfet_03v3 ad=1.12p pd=4.56u as=1.12p ps=4.56u w=4u l=1u
X16 a_n568_7311# a_n568_7311# vdd vdd pfet_03v3 ad=1.12p pd=4.56u as=2.4p ps=9.2u w=4u l=1u
X17 a_n568_7311# inp a_n688_3519# vss nfet_03v3 ad=1.12p pd=4.56u as=2.4p ps=9.2u w=4u l=1u
X18 vss vb a_n688_3519# vss nfet_03v3 ad=1.12p pd=4.56u as=1.12p ps=4.56u w=4u l=1u
X19 out a_n568_7311# vdd vdd pfet_03v3 ad=1.12p pd=4.56u as=2.4p ps=9.2u w=4u l=1u
.ends
