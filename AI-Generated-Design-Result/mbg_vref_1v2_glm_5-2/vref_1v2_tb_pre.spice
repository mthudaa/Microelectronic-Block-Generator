* Pre-layout testbench for vref_1v2 (MOSFET-only beta-multiplier Vref, ~0.75mW)
.include "/home/huda/.volare/gf180mcuD/libs.tech/ngspice/design.ngspice"
.lib "/home/huda/.volare/gf180mcuD/libs.tech/ngspice/sm141064.ngspice" typical
.include "vref_1v2_core.spice"

* Supply and instance
Vvdd vdd 0 DC 3.3
Vvss vss 0 DC 0
Xref vdd vss vref vref_1v2

* Load cap (user spec: CL = 1pF)
Cload vref 0 1p

.control
  set temp=27
  echo "=== 1. DC OPERATING POINT ==="
  op
  print v(vref)
  let pwr = 3.3 * i(Vvdd)
  print pwr

  echo "=== 2. DC SWEEP: Vref vs VDD (0 to 3.3V) ==="
  dc Vvdd 0 3.3 0.01
  write vref_dc.raw
  meas dc vref_at_3v3 find v(vref) at=3.3
  meas dc idd_at_3v3 find i(Vvdd) at=3.3

  echo "=== 3. TEMPERATURE SWEEP (-40 to 125C) ==="
  alter Vvdd DC 3.3
  dc temp -40 125 1
  write vref_temp.raw
  meas dc vref_t27 find v(vref) at=27
  meas dc vref_max max v(vref)
  meas dc vref_min min v(vref)

  echo "=== 4. TRANSIENT POWER-UP (startup) ==="
  alter Vvdd DC 0 PULSE(0 3.3 1u 1u 1u 10u 20u)
  set temp=27
  tran 100n 20u
  write vref_tran.raw

  echo "=== 5. CORNER DC OP ==="
  alter Vvdd DC 3.3
  set temp=27
  op
  print v(vref) i(Vvdd)

  echo "=== ALL SIMULATIONS COMPLETE ==="
.endc

.end
