* MOSFET-only Beta-Multiplier Voltage Reference — bare subcircuit
* (testbenches provide the GF180MCU model libraries; do NOT re-include here)
* Target: Vref = 1.2V @ VDD=3.3V, GF180MCU 3.3V, relaxed tempco (<200 ppm/C)
* Body: pfet_03v3 -> vdd, nfet_03v3 -> vss. All single-finger (nf=1) for
* router/LVS-friendly diode self-loops (see REPORT.md sec on LVS history).
.subckt vref_1v2 vdd vss vref
XM3  d1   d1   vdd  vdd  pfet_03v3 L=1.25u W=4u nf=1
XM4  d2   d1   vdd  vdd  pfet_03v3 L=1.25u W=4u nf=1
XM5  vref d1   vdd  vdd  pfet_03v3 L=1.25u W=4u nf=1
XM1  d1   d1   vss  vss  nfet_03v3 L=1.25u W=4u nf=1
XM2  d2   d1   src2 vss  nfet_03v3 L=1.25u W=4u nf=1
XM_r src2 vdd  vss  vss  nfet_03v3 L=1.25u W=4u nf=1
XM6  vref vref vss  vss  nfet_03v3 L=1u    W=4u nf=1
.ends
