* NGSPICE file created from vref_1v2.ext - technology: gf180mcuD

.subckt vref_1v2 vdd vss vref
X0 a_n125_7311# a_n125_7311# vss vss nfet_03v3 ad=2.4p pd=9.2u as=2.4p ps=9.2u w=4u l=1.25u
X1 a_3025_3519# a_n125_7311# a_2655_3519# vss nfet_03v3 ad=2.4p pd=9.2u as=2.4p ps=9.2u w=4u l=1.25u
X2 vref vref vss vss nfet_03v3 ad=2.4p pd=9.2u as=2.4p ps=9.2u w=4u l=1u
X3 a_2655_3519# vdd vss vss nfet_03v3 ad=2.4p pd=9.2u as=2.4p ps=9.2u w=4u l=1.25u
X4 a_n125_7311# a_n125_7311# vdd vdd pfet_03v3 ad=2.4p pd=9.2u as=2.4p ps=9.2u w=4u l=1.25u
X5 a_3025_3519# a_n125_7311# vdd vdd pfet_03v3 ad=2.4p pd=9.2u as=2.4p ps=9.2u w=4u l=1.25u
X6 vref a_n125_7311# vdd vdd pfet_03v3 ad=2.4p pd=9.2u as=2.4p ps=9.2u w=4u l=1.25u
.ends
