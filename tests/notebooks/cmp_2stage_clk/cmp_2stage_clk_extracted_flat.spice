* NGSPICE file created from cmp_2stage_clk.ext - technology: gf180mcuD

.subckt cmp_2stage_clk vdd vss inp inm clk out
X0 a_n3550_5456# out vdd vdd pfet_03v3 ad=1.44p pd=6u as=1.44p ps=6u w=2.4u l=0.8u
X1 a_n3550_5456# clk vdd vdd pfet_03v3 ad=0.9p pd=4.2u as=0.9p ps=4.2u w=1.5u l=0.8u
X2 out clk vdd vdd pfet_03v3 ad=0.9p pd=4.2u as=0.9p ps=4.2u w=1.5u l=0.8u
X3 a_n2018_5456# inp a_n2138_2966# vss nfet_03v3 ad=1.44p pd=6u as=1.44p ps=6u w=2.4u l=1u
X4 a_n646_2966# inm a_n2138_2966# vss nfet_03v3 ad=1.44p pd=6u as=1.44p ps=6u w=2.4u l=1u
X5 a_n2018_5456# a_n2018_5456# vdd vdd pfet_03v3 ad=0.9p pd=4.2u as=0.9p ps=4.2u w=1.5u l=1u
X6 a_n646_2966# a_n2018_5456# vdd vdd pfet_03v3 ad=0.9p pd=4.2u as=0.9p ps=4.2u w=1.5u l=1u
X7 a_n3550_5456# a_n2018_5456# a_606_2968# vss nfet_03v3 ad=1.08p pd=4.8u as=1.08p ps=4.8u w=1.8u l=0.8u
X8 a_606_2968# clk vss vss nfet_03v3 ad=0.96p pd=4.4u as=0.96p ps=4.4u w=1.6u l=0.8u
X9 out a_n3550_5456# vdd vdd pfet_03v3 ad=1.44p pd=6u as=1.44p ps=6u w=2.4u l=0.8u
X10 a_n2138_2966# clk vss vss nfet_03v3 ad=0.48p pd=2.8u as=0.48p ps=2.8u w=0.8u l=1u
X11 out a_n646_2966# a_606_2968# vss nfet_03v3 ad=1.08p pd=4.8u as=1.08p ps=4.8u w=1.8u l=0.8u
.ends
