* NGSPICE file created from cmp_2stage_clk.ext - technology: gf180mcuD

.subckt cmp_2stage_clk vdd vss inp inm clk out
X0 out a_686_5664# vdd vdd pfet_03v3 ad=1.44p pd=6u as=1.44p ps=6u w=2.4u l=0.8u
X1 a_n3350_5456# a_n3350_5456# vdd vdd pfet_03v3 ad=0.9p pd=4.2u as=0.9p ps=4.2u w=1.5u l=1u
X2 out clk vdd vdd pfet_03v3 ad=0.9p pd=4.2u as=0.9p ps=4.2u w=1.5u l=0.8u
X3 a_n3350_5456# inp a_n2138_2966# vss nfet_03v3 ad=1.44p pd=6u as=1.44p ps=6u w=2.4u l=1u
X4 a_n1978_5664# a_n3350_5456# vdd vdd pfet_03v3 ad=0.9p pd=4.2u as=0.9p ps=4.2u w=1.5u l=1u
X5 a_n1978_5664# inm a_n2138_2966# vss nfet_03v3 ad=1.44p pd=6u as=1.44p ps=6u w=2.4u l=1u
X6 a_686_5664# out vdd vdd pfet_03v3 ad=1.44p pd=6u as=1.44p ps=6u w=2.4u l=0.8u
X7 a_686_5664# a_n3350_5456# a_606_2968# vss nfet_03v3 ad=1.08p pd=4.8u as=1.08p ps=4.8u w=1.8u l=0.8u
X8 a_606_2968# clk vss vss nfet_03v3 ad=0.96p pd=4.4u as=0.96p ps=4.4u w=1.6u l=0.8u
X9 a_n2138_2966# clk vss vss nfet_03v3 ad=0.48p pd=2.8u as=0.48p ps=2.8u w=0.8u l=1u
X10 a_686_5664# clk vdd vdd pfet_03v3 ad=0.9p pd=4.2u as=0.9p ps=4.2u w=1.5u l=0.8u
X11 out a_n1978_5664# a_606_2968# vss nfet_03v3 ad=1.08p pd=4.8u as=1.08p ps=4.8u w=1.8u l=0.8u
.ends
