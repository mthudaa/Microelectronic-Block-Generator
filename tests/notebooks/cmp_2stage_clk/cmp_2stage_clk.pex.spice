* PEX produced on Wed Aug 26 09:57:20 PM CST 2026 using /home/huda/opensource-project/Microelectronic-Block-Generator/designs/notebooks/chipathon2026-D/scripts/iic-pex.sh with m=2 and s=1
* NGSPICE file created from cmp_2stage_clk.ext - technology: gf180mcuD

.option scale=5n

.subckt cmp_2stage_clk out clk inm inp vss vdd
X0 out a_686_5664# vdd vdd pfet_03v3 ad=57.6n pd=1.2m as=57.6n ps=1.2m w=480 l=160
X1 a_n3350_5456# a_n3350_5456# vdd vdd pfet_03v3 ad=36n pd=0.84m as=36n ps=0.84m w=300 l=200
X2 out clk vdd vdd pfet_03v3 ad=36n pd=0.84m as=36n ps=0.84m w=300 l=160
X3 a_n3350_5456# inp a_n2138_2966# vss nfet_03v3 ad=57.6n pd=1.2m as=57.6n ps=1.2m w=480 l=200
X4 a_n1978_5664# a_n3350_5456# vdd vdd pfet_03v3 ad=36n pd=0.84m as=36n ps=0.84m w=300 l=200
X5 a_n1978_5664# inm a_n2138_2966# vss nfet_03v3 ad=57.6n pd=1.2m as=57.6n ps=1.2m w=480 l=200
X6 a_686_5664# out vdd vdd pfet_03v3 ad=57.6n pd=1.2m as=57.6n ps=1.2m w=480 l=160
X7 a_686_5664# a_n3350_5456# a_606_2968# vss nfet_03v3 ad=43.2n pd=0.96m as=43.2n ps=0.96m w=360 l=160
X8 a_606_2968# clk vss vss nfet_03v3 ad=38.4n pd=0.88m as=38.4n ps=0.88m w=320 l=160
X9 a_n2138_2966# clk vss vss nfet_03v3 ad=19.2n pd=0.56m as=19.2n ps=0.56m w=160 l=200
X10 a_686_5664# clk vdd vdd pfet_03v3 ad=36n pd=0.84m as=36n ps=0.84m w=300 l=160
X11 out a_n1978_5664# a_606_2968# vss nfet_03v3 ad=43.2n pd=0.96m as=43.2n ps=0.96m w=360 l=160
C0 a_n1978_5664# inm 0.09973f
C1 a_n1978_5664# vdd 2.15444f
C2 vdd clk 1.7251f
C3 vdd a_686_5664# 4.3586f
C4 a_n1978_5664# a_606_2968# 0.13873f
C5 a_606_2968# clk 0.28789f
C6 a_606_2968# a_686_5664# 0.44803f
C7 a_n1978_5664# a_n3350_5456# 0.50289f
C8 a_n3350_5456# clk 0.08097f
C9 a_n3350_5456# a_686_5664# 0.05566f
C10 a_n1978_5664# out 0.17009f
C11 out clk 0.11801f
C12 out a_686_5664# 0.71932f
C13 a_n3350_5456# inp 0.08447f
C14 a_n1978_5664# a_n2138_2966# 0.60717f
C15 a_n2138_2966# clk 0.15798f
C16 a_n3350_5456# inm 0.02119f
C17 a_n3350_5456# vdd 3.86068f
C18 a_n3350_5456# a_606_2968# 0.38015f
C19 out vdd 5.08098f
C20 a_n2138_2966# inp 0.13563f
C21 a_n1978_5664# clk 0.58938f
C22 out a_606_2968# 0.69846f
C23 a_n2138_2966# inm 0.12656f
C24 clk a_686_5664# 0.07957f
C25 a_n3350_5456# out 0.03948f
C26 a_n3350_5456# a_n2138_2966# 1.02912f
C27 inm vss 0.64193f
C28 inp vss 0.65441f
C29 out vss 2.25425f
C30 clk vss 3.49948f
C31 vdd vss 33.6603f
C32 a_606_2968# vss 2.9678f ; **FLOATING
C33 a_n2138_2966# vss 4.04982f ; **FLOATING
C34 a_686_5664# vss 2.35112f ; **FLOATING
C35 a_n1978_5664# vss 2.79589f ; **FLOATING
C36 a_n3350_5456# vss 3.76779f ; **FLOATING
.ends
