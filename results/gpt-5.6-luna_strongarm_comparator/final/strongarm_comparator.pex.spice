* PEX produced on Fri Aug 28 06:42:38 AM CST 2026 using /home/huda/opensource-project/Microelectronic-Block-Generator/designs/notebooks/chipathon2026-D/scripts/iic-pex.sh with m=2 and s=1
* NGSPICE file created from strongarm_comparator.ext - technology: gf180mcuD

.option scale=5n

.subckt strongarm_comparator OUTN OUTP CLK INN INP VSS VDD
X0 VDD CLK a_n3274_8269# VDD pfet_03v3 ad=11.2n pd=0.312m as=11.2n ps=0.312m w=200 l=120
X1 VDD CLK OUTN VDD pfet_03v3 ad=11.2n pd=0.312m as=11.2n ps=0.312m w=200 l=120
X2 OUTP CLK VDD VDD pfet_03v3 ad=11.2n pd=0.312m as=24n ps=0.64m w=200 l=120
X3 VDD OUTN OUTP VDD pfet_03v3 ad=11.2n pd=0.312m as=11.2n ps=0.312m w=200 l=120
X4 a_n3274_8269# INN a_n3878_4349# VSS nfet_03v3 ad=11.2n pd=0.312m as=24n ps=0.64m w=200 l=120
X5 a_n4930_8269# OUTP OUTN VSS nfet_03v3 ad=11.2n pd=0.312m as=11.2n ps=0.312m w=200 l=120
X6 OUTN CLK VDD VDD pfet_03v3 ad=11.2n pd=0.312m as=24n ps=0.64m w=200 l=120
X7 OUTN OUTP a_n4930_8269# VSS nfet_03v3 ad=24n pd=0.64m as=11.2n ps=0.312m w=200 l=120
X8 a_n3274_8269# CLK VDD VDD pfet_03v3 ad=11.2n pd=0.312m as=24n ps=0.64m w=200 l=120
X9 OUTN CLK VDD VDD pfet_03v3 ad=24n pd=0.64m as=11.2n ps=0.312m w=200 l=120
X10 OUTP OUTN VDD VDD pfet_03v3 ad=24n pd=0.64m as=11.2n ps=0.312m w=200 l=120
X11 OUTN OUTP VDD VDD pfet_03v3 ad=11.2n pd=0.312m as=24n ps=0.64m w=200 l=120
X12 OUTN OUTP a_n4930_8269# VSS nfet_03v3 ad=11.2n pd=0.312m as=11.2n ps=0.312m w=200 l=120
X13 VDD CLK a_n4930_8269# VDD pfet_03v3 ad=11.2n pd=0.312m as=11.2n ps=0.312m w=200 l=120
X14 a_n3878_4349# CLK VSS VSS nfet_03v3 ad=11.2n pd=0.312m as=24n ps=0.64m w=200 l=120
X15 VDD CLK OUTP VDD pfet_03v3 ad=11.2n pd=0.312m as=11.2n ps=0.312m w=200 l=120
X16 OUTN OUTP a_n4930_8269# VSS nfet_03v3 ad=11.2n pd=0.312m as=24n ps=0.64m w=200 l=120
X17 a_n3274_8269# OUTN OUTP VSS nfet_03v3 ad=11.2n pd=0.312m as=11.2n ps=0.312m w=200 l=120
X18 a_n3878_4349# CLK VSS VSS nfet_03v3 ad=11.2n pd=0.312m as=11.2n ps=0.312m w=200 l=120
X19 a_n4930_8269# OUTP OUTN VSS nfet_03v3 ad=11.2n pd=0.312m as=11.2n ps=0.312m w=200 l=120
X20 a_n4930_8269# CLK VDD VDD pfet_03v3 ad=24n pd=0.64m as=11.2n ps=0.312m w=200 l=120
X21 a_n3274_8269# CLK VDD VDD pfet_03v3 ad=24n pd=0.64m as=11.2n ps=0.312m w=200 l=120
X22 OUTP CLK VDD VDD pfet_03v3 ad=24n pd=0.64m as=11.2n ps=0.312m w=200 l=120
X23 OUTP OUTN a_n3274_8269# VSS nfet_03v3 ad=24n pd=0.64m as=11.2n ps=0.312m w=200 l=120
X24 OUTP OUTN a_n3274_8269# VSS nfet_03v3 ad=11.2n pd=0.312m as=11.2n ps=0.312m w=200 l=120
X25 a_n3274_8269# INN a_n3878_4349# VSS nfet_03v3 ad=24n pd=0.64m as=11.2n ps=0.312m w=200 l=120
X26 VDD OUTP OUTN VDD pfet_03v3 ad=11.2n pd=0.312m as=11.2n ps=0.312m w=200 l=120
X27 a_n4930_8269# CLK VDD VDD pfet_03v3 ad=11.2n pd=0.312m as=24n ps=0.64m w=200 l=120
X28 a_n3878_4349# INP a_n4930_8269# VSS nfet_03v3 ad=11.2n pd=0.312m as=11.2n ps=0.312m w=200 l=120
X29 a_n3878_4349# INN a_n3274_8269# VSS nfet_03v3 ad=11.2n pd=0.312m as=11.2n ps=0.312m w=200 l=120
X30 OUTN OUTP VDD VDD pfet_03v3 ad=24n pd=0.64m as=11.2n ps=0.312m w=200 l=120
X31 a_n4930_8269# INP a_n3878_4349# VSS nfet_03v3 ad=11.2n pd=0.312m as=24n ps=0.64m w=200 l=120
X32 a_n4930_8269# INP a_n3878_4349# VSS nfet_03v3 ad=24n pd=0.64m as=11.2n ps=0.312m w=200 l=120
X33 OUTP OUTN a_n3274_8269# VSS nfet_03v3 ad=11.2n pd=0.312m as=24n ps=0.64m w=200 l=120
X34 VSS CLK a_n3878_4349# VSS nfet_03v3 ad=24n pd=0.64m as=11.2n ps=0.312m w=200 l=120
X35 OUTP OUTN VDD VDD pfet_03v3 ad=11.2n pd=0.312m as=24n ps=0.64m w=200 l=120
X36 a_n3274_8269# OUTN OUTP VSS nfet_03v3 ad=11.2n pd=0.312m as=11.2n ps=0.312m w=200 l=120
X37 VSS CLK a_n3878_4349# VSS nfet_03v3 ad=11.2n pd=0.312m as=11.2n ps=0.312m w=200 l=120
C0 a_n4930_8269# CLK 0.30369f
C1 CLK OUTN 0.21888f
C2 a_n3878_4349# INP 0.24237f
C3 a_n4930_8269# OUTN 1.83943f
C4 VDD OUTP 7.02603f
C5 a_n3878_4349# a_n3274_8269# 1.37005f
C6 VDD CLK 8.50366f
C7 a_n4930_8269# VDD 2.65684f
C8 VDD OUTN 7.9219f
C9 a_n3878_4349# CLK 0.48673f
C10 a_n3274_8269# OUTP 2.01726f
C11 a_n3878_4349# a_n4930_8269# 1.36771f
C12 a_n4930_8269# INP 0.1484f
C13 a_n3274_8269# CLK 0.37018f
C14 a_n3878_4349# INN 0.25304f
C15 a_n3274_8269# a_n4930_8269# 0.99149f
C16 a_n3274_8269# OUTN 0.58984f
C17 a_n3274_8269# INN 0.14972f
C18 CLK OUTP 0.17786f
C19 a_n4930_8269# OUTP 0.37272f
C20 a_n3274_8269# VDD 2.58006f
C21 OUTN OUTP 2.31275f
C22 INN VSS 1.58736f
C23 INP VSS 1.44723f
C24 OUTP VSS 6.41662f
C25 OUTN VSS 7.02227f
C26 CLK VSS 6.1644f
C27 VDD VSS 41.8773f
C28 a_n3878_4349# VSS 5.85173f ; **FLOATING
C29 a_n3274_8269# VSS 4.946f ; **FLOATING
C30 a_n4930_8269# VSS 4.19481f ; **FLOATING
.ends
