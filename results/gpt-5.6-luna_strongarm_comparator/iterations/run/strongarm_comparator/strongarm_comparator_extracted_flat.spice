* NGSPICE file created from strongarm_comparator.ext - technology: gf180mcuD

.subckt strongarm_comparator VDD VSS INP INN CLK OUTP OUTN
X0 a_n3842_8269# CLK VDD VDD pfet_03v3 ad=0.28p pd=1.56u as=0.6p ps=3.2u w=1u l=0.6u
X1 OUTP OUTN a_n3842_8269# VSS nfet_03v3 ad=0.28p pd=1.56u as=0.28p ps=1.56u w=1u l=0.6u
X2 OUTP OUTN VDD VDD pfet_03v3 ad=0.28p pd=1.56u as=0.6p ps=3.2u w=1u l=0.6u
X3 OUTN CLK VDD VDD pfet_03v3 ad=0.28p pd=1.56u as=0.6p ps=3.2u w=1u l=0.6u
X4 a_n4546_4349# CLK VSS VSS nfet_03v3 ad=0.28p pd=1.56u as=0.6p ps=3.2u w=1u l=0.6u
X5 a_n4546_4349# CLK VSS VSS nfet_03v3 ad=0.28p pd=1.56u as=0.28p ps=1.56u w=1u l=0.6u
X6 VDD CLK OUTN VDD pfet_03v3 ad=0.28p pd=1.56u as=0.28p ps=1.56u w=1u l=0.6u
X7 VDD CLK OUTP VDD pfet_03v3 ad=0.28p pd=1.56u as=0.28p ps=1.56u w=1u l=0.6u
X8 a_n5398_8269# OUTP OUTN VSS nfet_03v3 ad=0.28p pd=1.56u as=0.28p ps=1.56u w=1u l=0.6u
X9 a_n5398_8269# OUTP OUTN VSS nfet_03v3 ad=0.28p pd=1.56u as=0.28p ps=1.56u w=1u l=0.6u
X10 OUTP OUTN a_n3842_8269# VSS nfet_03v3 ad=0.6p pd=3.2u as=0.28p ps=1.56u w=1u l=0.6u
X11 OUTP CLK VDD VDD pfet_03v3 ad=0.28p pd=1.56u as=0.6p ps=3.2u w=1u l=0.6u
X12 OUTP CLK VDD VDD pfet_03v3 ad=0.6p pd=3.2u as=0.28p ps=1.56u w=1u l=0.6u
X13 a_n5398_8269# INP a_n4546_4349# VSS nfet_03v3 ad=0.6p pd=3.2u as=0.28p ps=1.56u w=1u l=0.6u
X14 OUTN OUTP a_n5398_8269# VSS nfet_03v3 ad=0.28p pd=1.56u as=0.28p ps=1.56u w=1u l=0.6u
X15 a_n3842_8269# OUTN OUTP VSS nfet_03v3 ad=0.28p pd=1.56u as=0.28p ps=1.56u w=1u l=0.6u
X16 VDD OUTN OUTP VDD pfet_03v3 ad=0.28p pd=1.56u as=0.28p ps=1.56u w=1u l=0.6u
X17 a_n3842_8269# INN a_n4546_4349# VSS nfet_03v3 ad=0.6p pd=3.2u as=0.28p ps=1.56u w=1u l=0.6u
X18 OUTN OUTP VDD VDD pfet_03v3 ad=0.6p pd=3.2u as=0.28p ps=1.56u w=1u l=0.6u
X19 OUTP OUTN VDD VDD pfet_03v3 ad=0.6p pd=3.2u as=0.28p ps=1.56u w=1u l=0.6u
X20 a_n4546_4349# INN a_n3842_8269# VSS nfet_03v3 ad=0.28p pd=1.56u as=0.28p ps=1.56u w=1u l=0.6u
X21 VDD CLK a_n3842_8269# VDD pfet_03v3 ad=0.28p pd=1.56u as=0.28p ps=1.56u w=1u l=0.6u
X22 OUTN OUTP VDD VDD pfet_03v3 ad=0.28p pd=1.56u as=0.6p ps=3.2u w=1u l=0.6u
X23 OUTN OUTP a_n5398_8269# VSS nfet_03v3 ad=0.6p pd=3.2u as=0.28p ps=1.56u w=1u l=0.6u
X24 VDD OUTP OUTN VDD pfet_03v3 ad=0.28p pd=1.56u as=0.28p ps=1.56u w=1u l=0.6u
X25 a_n5398_8269# INP a_n4546_4349# VSS nfet_03v3 ad=0.28p pd=1.56u as=0.6p ps=3.2u w=1u l=0.6u
X26 a_n3842_8269# INN a_n4546_4349# VSS nfet_03v3 ad=0.28p pd=1.56u as=0.6p ps=3.2u w=1u l=0.6u
X27 a_n5398_8269# CLK VDD VDD pfet_03v3 ad=0.28p pd=1.56u as=0.6p ps=3.2u w=1u l=0.6u
X28 a_n5398_8269# CLK VDD VDD pfet_03v3 ad=0.6p pd=3.2u as=0.28p ps=1.56u w=1u l=0.6u
X29 a_n3842_8269# CLK VDD VDD pfet_03v3 ad=0.6p pd=3.2u as=0.28p ps=1.56u w=1u l=0.6u
X30 OUTN CLK VDD VDD pfet_03v3 ad=0.6p pd=3.2u as=0.28p ps=1.56u w=1u l=0.6u
X31 OUTP OUTN a_n3842_8269# VSS nfet_03v3 ad=0.28p pd=1.56u as=0.6p ps=3.2u w=1u l=0.6u
X32 VSS CLK a_n4546_4349# VSS nfet_03v3 ad=0.6p pd=3.2u as=0.28p ps=1.56u w=1u l=0.6u
X33 OUTN OUTP a_n5398_8269# VSS nfet_03v3 ad=0.28p pd=1.56u as=0.6p ps=3.2u w=1u l=0.6u
X34 a_n4546_4349# INP a_n5398_8269# VSS nfet_03v3 ad=0.28p pd=1.56u as=0.28p ps=1.56u w=1u l=0.6u
X35 VSS CLK a_n4546_4349# VSS nfet_03v3 ad=0.28p pd=1.56u as=0.28p ps=1.56u w=1u l=0.6u
X36 VDD CLK a_n5398_8269# VDD pfet_03v3 ad=0.28p pd=1.56u as=0.28p ps=1.56u w=1u l=0.6u
X37 a_n3842_8269# OUTN OUTP VSS nfet_03v3 ad=0.28p pd=1.56u as=0.28p ps=1.56u w=1u l=0.6u
.ends
