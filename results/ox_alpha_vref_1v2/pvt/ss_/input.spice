.include '/home/huda/.volare/gf180mcuD/libs.tech/ngspice/design.ngspice'
.lib '/home/huda/.volare/gf180mcuD/libs.tech/ngspice/sm141064.ngspice' ss

* PEX produced on Sun Aug 23 06:16:06 AM CST 2026 using /home/huda/opensource-project/Microelectronic-Block-Generator/designs/notebooks/chipathon2026-D/scripts/iic-pex.sh with m=2 and s=1
* NGSPICE file created from vref_1v2.ext - technology: gf180mcuD

.option scale=5n

.subckt vref_1v2 IBIAS VREF VSS VDD
X0 VREF VREF a_n777_428# VSS nfet_03v3 ad=8.96n pd=0.272m as=19.2n ps=0.56m w=160 l=70
X1 VREF VREF a_n777_428# VSS nfet_03v3 ad=8.96n pd=0.272m as=8.96n ps=0.272m w=160 l=70
X2 a_n777_428# VREF VREF VSS nfet_03v3 ad=8.96n pd=0.272m as=8.96n ps=0.272m w=160 l=70
X3 VREF VREF a_n777_428# VSS nfet_03v3 ad=8.96n pd=0.272m as=8.96n ps=0.272m w=160 l=70
X4 a_n777_428# VREF VREF VSS nfet_03v3 ad=19.2n pd=0.56m as=8.96n ps=0.272m w=160 l=70
X5 a_n777_428# VREF VREF VSS nfet_03v3 ad=8.96n pd=0.272m as=8.96n ps=0.272m w=160 l=70
X6 a_n777_428# VREF VREF VSS nfet_03v3 ad=8.96n pd=0.272m as=8.96n ps=0.272m w=160 l=70
X7 a_n777_428# VREF VSS VSS nfet_03v3 ad=0.228u pd=4.04m as=0.228u ps=4.04m w=1900 l=1490
X8 VREF VREF a_n777_428# VSS nfet_03v3 ad=8.96n pd=0.272m as=8.96n ps=0.272m w=160 l=70
X9 IBIAS IBIAS VDD VDD pfet_03v3 ad=48n pd=1.04m as=48n ps=1.04m w=400 l=1600
X10 VREF VREF a_n777_428# VSS nfet_03v3 ad=8.96n pd=0.272m as=8.96n ps=0.272m w=160 l=70
X11 a_n777_428# VREF VREF VSS nfet_03v3 ad=8.96n pd=0.272m as=8.96n ps=0.272m w=160 l=70
X12 a_n777_428# VREF VREF VSS nfet_03v3 ad=8.96n pd=0.272m as=8.96n ps=0.272m w=160 l=70
X13 VREF IBIAS VDD VDD pfet_03v3 ad=48n pd=1.04m as=48n ps=1.04m w=400 l=1600
X14 VREF VREF a_n777_428# VSS nfet_03v3 ad=8.96n pd=0.272m as=8.96n ps=0.272m w=160 l=70
C0 VDD VREF 2.96946f
C1 IBIAS VREF 0.31572f
C2 a_n777_428# VREF 6.07241f
C3 VDD IBIAS 11.5815f
C4 VDD a_n777_428# 0.02131f
C5 VREF VSS 13.925f
C6 IBIAS VSS 0.72425f
C7 VDD VSS 26.7666f
C8 a_n777_428# VSS 6.1675f ; **FLOATING
.ends

Vsupply0 VDD 0 3.3
Vsupply1 VSS 0 0.0
C_load_VREF VREF 0 1p
.option temp=125
IBIN IBIAS VSS DC 20u
Xdut IBIAS VREF VSS VDD vref_1v2

.control
dc Vsupply0 2.7 3.6 0.05
wrdata dc.dat v(VREF)
.endc
.end
