* PEX produced on Thu Aug 27 11:23:38 AM CST 2026 using /home/huda/opensource-project/Microelectronic-Block-Generator/designs/notebooks/chipathon2026-D/scripts/iic-pex.sh with m=2 and s=1
* NGSPICE file created from vref_1v2.ext - technology: gf180mcuD

.option scale=5n

.subckt vref_1v2 IBIAS VREF VSS VDD
X0 VREF VREF a_n777_428# VSS nfet_03v3 ad=8.96n pd=0.272m as=19.2n ps=0.56m w=160 l=70
X1 VREF VREF a_n777_428# VSS nfet_03v3 ad=8.96n pd=0.272m as=8.96n ps=0.272m w=160 l=70
X2 VREF IBIAS VDD VDD pfet_03v3 ad=48n pd=1.04m as=48n ps=1.04m w=400 l=1600
X3 a_n777_428# VREF VREF VSS nfet_03v3 ad=8.96n pd=0.272m as=8.96n ps=0.272m w=160 l=70
X4 VREF VREF a_n777_428# VSS nfet_03v3 ad=8.96n pd=0.272m as=8.96n ps=0.272m w=160 l=70
X5 a_n777_428# VREF VREF VSS nfet_03v3 ad=19.2n pd=0.56m as=8.96n ps=0.272m w=160 l=70
X6 a_n777_428# VREF VREF VSS nfet_03v3 ad=8.96n pd=0.272m as=8.96n ps=0.272m w=160 l=70
X7 a_n777_428# VREF VREF VSS nfet_03v3 ad=8.96n pd=0.272m as=8.96n ps=0.272m w=160 l=70
X8 a_n777_428# VREF VSS VSS nfet_03v3 ad=0.228u pd=4.04m as=0.228u ps=4.04m w=1900 l=1490
X9 VREF VREF a_n777_428# VSS nfet_03v3 ad=8.96n pd=0.272m as=8.96n ps=0.272m w=160 l=70
X10 VREF VREF a_n777_428# VSS nfet_03v3 ad=8.96n pd=0.272m as=8.96n ps=0.272m w=160 l=70
X11 a_n777_428# VREF VREF VSS nfet_03v3 ad=8.96n pd=0.272m as=8.96n ps=0.272m w=160 l=70
X12 IBIAS IBIAS VDD VDD pfet_03v3 ad=48n pd=1.04m as=48n ps=1.04m w=400 l=1600
X13 a_n777_428# VREF VREF VSS nfet_03v3 ad=8.96n pd=0.272m as=8.96n ps=0.272m w=160 l=70
X14 VREF VREF a_n777_428# VSS nfet_03v3 ad=8.96n pd=0.272m as=8.96n ps=0.272m w=160 l=70
C0 VDD IBIAS 11.6422f
C1 VDD a_n777_428# 0.01963f
C2 VDD VREF 2.95473f
C3 IBIAS VREF 0.31632f
C4 a_n777_428# VREF 6.07241f
C5 VREF VSS 13.9348f
C6 IBIAS VSS 0.77882f
C7 VDD VSS 26.8589f
C8 a_n777_428# VSS 6.16998f ; **FLOATING
.ends
