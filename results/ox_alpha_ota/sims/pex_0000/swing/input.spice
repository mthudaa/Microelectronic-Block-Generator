.include '/home/huda/.volare/gf180mcuD/libs.tech/ngspice/design.ngspice'
.lib '/home/huda/.volare/gf180mcuD/libs.tech/ngspice/sm141064.ngspice' typical
.temp 27
* PEX produced on Sun Aug 23 04:47:13 AM CST 2026 using /home/huda/opensource-project/Microelectronic-Block-Generator/designs/notebooks/chipathon2026-D/scripts/iic-pex.sh with m=2 and s=1
* NGSPICE file created from ota.ext - technology: gf180mcuD

.option scale=5n

.subckt ota IBIAS OUT INN INP VSS VDD
X0 a_n4822_7056# a_n4822_7056# VDD VDD pfet_03v3 ad=84n pd=1.612m as=84n ps=1.612m w=1500 l=1000
X1 a_n4822_7056# INN a_n1006_3846# VSS nfet_03v3 ad=0.144u pd=2.64m as=0.144u ps=2.64m w=1200 l=400
X2 VDD a_n4822_7056# a_n4822_7056# VDD pfet_03v3 ad=0.18u pd=3.24m as=84n ps=1.612m w=1500 l=1000
X3 OUT a_n4822_7056# VDD VDD pfet_03v3 ad=84n pd=1.612m as=0.18u ps=3.24m w=1500 l=1000
X4 IBIAS IBIAS VSS VSS nfet_03v3 ad=48n pd=1.04m as=48n ps=1.04m w=400 l=400
X5 a_n1006_3846# IBIAS VSS VSS nfet_03v3 ad=67.2n pd=1.312m as=0.144u ps=2.64m w=1200 l=800
X6 VDD a_n4822_7056# OUT VDD pfet_03v3 ad=0.18u pd=3.24m as=84n ps=1.612m w=1500 l=1000
X7 VDD a_n4822_7056# a_n4822_7056# VDD pfet_03v3 ad=84n pd=1.612m as=84n ps=1.612m w=1500 l=1000
X8 a_n4822_7056# a_n4822_7056# VDD VDD pfet_03v3 ad=84n pd=1.612m as=0.18u ps=3.24m w=1500 l=1000
X9 OUT a_n4822_7056# VDD VDD pfet_03v3 ad=84n pd=1.612m as=84n ps=1.612m w=1500 l=1000
X10 VDD a_n4822_7056# OUT VDD pfet_03v3 ad=84n pd=1.612m as=84n ps=1.612m w=1500 l=1000
X11 OUT INP a_n1006_3846# VSS nfet_03v3 ad=0.144u pd=2.64m as=0.144u ps=2.64m w=1200 l=400
X12 VSS IBIAS a_n1006_3846# VSS nfet_03v3 ad=0.144u pd=2.64m as=67.2n ps=1.312m w=1200 l=800
C0 IBIAS a_n1006_3846# 0.83587f
C1 OUT a_n4822_7056# 2.68435f
C2 a_n4822_7056# INN 0.29534f
C3 a_n4822_7056# a_n1006_3846# 0.77079f
C4 VDD a_n4822_7056# 29.9492f
C5 OUT INP 0.32108f
C6 INP a_n1006_3846# 0.38482f
C7 OUT a_n1006_3846# 0.69163f
C8 INN a_n1006_3846# 0.43136f
C9 OUT VDD 6.18086f
C10 IBIAS VSS 9.60176f
C11 INP VSS 1.08839f
C12 INN VSS 1.0837f
C13 OUT VSS 2.84577f
C14 VDD VSS 87.9648f
C15 a_n1006_3846# VSS 6.38384f ; **FLOATING
C16 a_n4822_7056# VSS 3.73418f ; **FLOATING
.ends
XDUT IBIAS OUT INN INP VSS VDD ota
VVDD VDD 0 3.3
VVSS VSS 0 0
VINP INP 0 DC 0
VINN INN 0 DC 1.65
CLOAD OUT 0 5.0p
IIB 0 IBIAS DC 20.0u
.control
dc VINP 0 3.3 0.01
wrdata dc.dat v(OUT)
quit
.endc
.end
