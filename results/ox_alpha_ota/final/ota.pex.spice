* PEX produced on Thu Aug 27 11:22:10 AM CST 2026 using /home/huda/opensource-project/Microelectronic-Block-Generator/designs/notebooks/chipathon2026-D/scripts/iic-pex.sh with m=2 and s=1
* NGSPICE file created from ota.ext - technology: gf180mcuD

.option scale=5n

.subckt ota IBIAS OUT INN INP VSS VDD
X0 a_n4072_7056# INN a_n1006_3846# VSS nfet_03v3 ad=0.144u pd=2.64m as=0.144u ps=2.64m w=1200 l=400
X1 a_n4072_7056# a_n4072_7056# VDD VDD pfet_03v3 ad=84n pd=1.612m as=0.18u ps=3.24m w=1500 l=800
X2 OUT a_n4072_7056# VDD VDD pfet_03v3 ad=84n pd=1.612m as=84n ps=1.612m w=1500 l=800
X3 a_n4072_7056# a_n4072_7056# VDD VDD pfet_03v3 ad=84n pd=1.612m as=84n ps=1.612m w=1500 l=800
X4 IBIAS IBIAS VSS VSS nfet_03v3 ad=48n pd=1.04m as=48n ps=1.04m w=400 l=400
X5 VDD a_n4072_7056# OUT VDD pfet_03v3 ad=0.18u pd=3.24m as=84n ps=1.612m w=1500 l=800
X6 a_n1006_3846# IBIAS VSS VSS nfet_03v3 ad=67.2n pd=1.312m as=0.144u ps=2.64m w=1200 l=800
X7 VDD a_n4072_7056# a_n4072_7056# VDD pfet_03v3 ad=84n pd=1.612m as=84n ps=1.612m w=1500 l=800
X8 OUT a_n4072_7056# VDD VDD pfet_03v3 ad=84n pd=1.612m as=0.18u ps=3.24m w=1500 l=800
X9 VDD a_n4072_7056# OUT VDD pfet_03v3 ad=84n pd=1.612m as=84n ps=1.612m w=1500 l=800
X10 VDD a_n4072_7056# a_n4072_7056# VDD pfet_03v3 ad=0.18u pd=3.24m as=84n ps=1.612m w=1500 l=800
X11 OUT INP a_n1006_3846# VSS nfet_03v3 ad=0.144u pd=2.64m as=0.144u ps=2.64m w=1200 l=400
X12 VSS IBIAS a_n1006_3846# VSS nfet_03v3 ad=0.144u pd=2.64m as=67.2n ps=1.312m w=1200 l=800
C0 IBIAS a_n1006_3846# 0.84299f
C1 OUT a_n4072_7056# 2.47509f
C2 a_n4072_7056# INN 0.30904f
C3 a_n4072_7056# a_n1006_3846# 0.73792f
C4 VDD a_n4072_7056# 25.7127f
C5 OUT INP 0.32695f
C6 INP a_n1006_3846# 0.40033f
C7 OUT a_n1006_3846# 0.64531f
C8 INN a_n1006_3846# 0.39671f
C9 OUT VDD 5.24014f
C10 IBIAS VSS 9.78324f
C11 INP VSS 1.08263f
C12 INN VSS 1.08986f
C13 OUT VSS 2.44062f
C14 VDD VSS 74.5714f
C15 a_n1006_3846# VSS 6.51061f ; **FLOATING
C16 a_n4072_7056# VSS 3.53467f ; **FLOATING
.ends
