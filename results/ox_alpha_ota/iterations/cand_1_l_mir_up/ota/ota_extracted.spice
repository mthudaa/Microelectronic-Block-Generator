* NGSPICE file created from ota.ext - technology: gf180mcuD

.subckt ota IBIAS OUT INN INP VSS VDD
X0 a_n4822_7056# a_n4822_7056# VDD VDD pfet_03v3 ad=2.1p pd=8.06u as=2.1p ps=8.06u w=7.5u l=5u
X1 a_n4822_7056# INN a_n1006_3846# VSS nfet_03v3 ad=3.6p pd=13.2u as=3.6p ps=13.2u w=6u l=2u
X2 VDD a_n4822_7056# a_n4822_7056# VDD pfet_03v3 ad=4.5p pd=16.2u as=2.1p ps=8.06u w=7.5u l=5u
X3 OUT a_n4822_7056# VDD VDD pfet_03v3 ad=2.1p pd=8.06u as=4.5p ps=16.2u w=7.5u l=5u
X4 IBIAS IBIAS VSS VSS nfet_03v3 ad=1.2p pd=5.2u as=1.2p ps=5.2u w=2u l=2u
X5 a_n1006_3846# IBIAS VSS VSS nfet_03v3 ad=1.68p pd=6.56u as=3.6p ps=13.2u w=6u l=4u
X6 VDD a_n4822_7056# OUT VDD pfet_03v3 ad=4.5p pd=16.2u as=2.1p ps=8.06u w=7.5u l=5u
X7 VDD a_n4822_7056# a_n4822_7056# VDD pfet_03v3 ad=2.1p pd=8.06u as=2.1p ps=8.06u w=7.5u l=5u
X8 a_n4822_7056# a_n4822_7056# VDD VDD pfet_03v3 ad=2.1p pd=8.06u as=4.5p ps=16.2u w=7.5u l=5u
X9 OUT a_n4822_7056# VDD VDD pfet_03v3 ad=2.1p pd=8.06u as=2.1p ps=8.06u w=7.5u l=5u
X10 VDD a_n4822_7056# OUT VDD pfet_03v3 ad=2.1p pd=8.06u as=2.1p ps=8.06u w=7.5u l=5u
X11 OUT INP a_n1006_3846# VSS nfet_03v3 ad=3.6p pd=13.2u as=3.6p ps=13.2u w=6u l=2u
X12 VSS IBIAS a_n1006_3846# VSS nfet_03v3 ad=3.6p pd=13.2u as=1.68p ps=6.56u w=6u l=4u
.ends
