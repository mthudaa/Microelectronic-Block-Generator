* PEX produced on Sun Aug 23 04:47:53 AM CST 2026 using /home/huda/opensource-project/Microelectronic-Block-Generator/designs/notebooks/chipathon2026-D/scripts/iic-pex.sh with m=2 and s=1
* NGSPICE file created from ota.ext - technology: gf180mcuD

.option scale=5n

.subckt ota IBIAS OUT INN INP VSS VDD
X0 a_n4022_7056# a_n4022_7056# VDD VDD pfet_03v3 ad=84n pd=1.612m as=84n ps=1.612m w=1500 l=800
X1 VDD a_n4022_7056# OUT VDD pfet_03v3 ad=0.18u pd=3.24m as=84n ps=1.612m w=1500 l=800
X2 VDD a_n4022_7056# a_n4022_7056# VDD pfet_03v3 ad=84n pd=1.612m as=84n ps=1.612m w=1500 l=800
X3 OUT a_n4022_7056# VDD VDD pfet_03v3 ad=84n pd=1.612m as=0.18u ps=3.24m w=1500 l=800
X4 VDD a_n4022_7056# OUT VDD pfet_03v3 ad=84n pd=1.612m as=84n ps=1.612m w=1500 l=800
X5 IBIAS IBIAS VSS VSS nfet_03v3 ad=48n pd=1.04m as=48n ps=1.04m w=400 l=400
X6 a_n1206_3846# IBIAS VSS VSS nfet_03v3 ad=67.2n pd=1.312m as=0.144u ps=2.64m w=1200 l=800
X7 VDD a_n4022_7056# a_n4022_7056# VDD pfet_03v3 ad=0.18u pd=3.24m as=84n ps=1.612m w=1500 l=800
X8 a_n4022_7056# a_n4022_7056# VDD VDD pfet_03v3 ad=84n pd=1.612m as=0.18u ps=3.24m w=1500 l=800
X9 a_n4022_7056# INN a_n1206_3846# VSS nfet_03v3 ad=0.144u pd=2.64m as=0.144u ps=2.64m w=1200 l=600
X10 OUT a_n4022_7056# VDD VDD pfet_03v3 ad=84n pd=1.612m as=84n ps=1.612m w=1500 l=800
X11 OUT INP a_n1206_3846# VSS nfet_03v3 ad=0.144u pd=2.64m as=0.144u ps=2.64m w=1200 l=600
X12 VSS IBIAS a_n1206_3846# VSS nfet_03v3 ad=0.144u pd=2.64m as=67.2n ps=1.312m w=1200 l=800
C0 OUT a_n1206_3846# 0.69817f
C1 INN a_n1206_3846# 0.604f
C2 OUT VDD 5.59436f
C3 IBIAS a_n1206_3846# 0.83582f
C4 OUT a_n4022_7056# 2.72501f
C5 a_n4022_7056# INN 0.34886f
C6 a_n4022_7056# a_n1206_3846# 0.90645f
C7 VDD a_n4022_7056# 25.6879f
C8 OUT INP 0.40604f
C9 INP a_n1206_3846# 0.4792f
C10 IBIAS VSS 9.63776f
C11 INP VSS 1.50679f
C12 INN VSS 1.50479f
C13 OUT VSS 2.85463f
C14 VDD VSS 74.3109f
C15 a_n1206_3846# VSS 6.5322f ; **FLOATING
C16 a_n4022_7056# VSS 3.46578f ; **FLOATING
.ends
