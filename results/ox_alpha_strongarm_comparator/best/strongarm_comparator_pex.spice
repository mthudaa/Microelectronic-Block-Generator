* PEX produced on Sun Aug 23 03:45:12 PM CST 2026 using /home/huda/opensource-project/Microelectronic-Block-Generator/designs/notebooks/chipathon2026-D/scripts/iic-pex.sh with m=2 and s=1
* NGSPICE file created from strongarm_comparator.ext - technology: gf180mcuD

.option scale=5n

.subckt strongarm_comparator OUTN OUTP CLK INN INP VSS VDD
X0 OUTP OUTN VDD VDD pfet_03v3 ad=72n pd=1.44m as=72n ps=1.44m w=600 l=100
X1 a_n2018_4466# CLK VSS VSS nfet_03v3 ad=0.2184u pd=3.88m as=0.2184u ps=3.88m w=1820 l=100
X2 OUTN OUTP VDD VDD pfet_03v3 ad=72n pd=1.44m as=72n ps=1.44m w=600 l=100
X3 a_n1958_7284# INN a_n2018_4466# VSS nfet_03v3 ad=72n pd=1.44m as=72n ps=1.44m w=600 l=140
X4 OUTP OUTN a_n1958_7284# VSS nfet_03v3 ad=55.2n pd=1.16m as=55.2n ps=1.16m w=460 l=100
X5 OUTN OUTP a_n3030_7284# VSS nfet_03v3 ad=55.2n pd=1.16m as=55.2n ps=1.16m w=460 l=100
X6 OUTN CLK VDD VDD pfet_03v3 ad=38.4n pd=0.88m as=38.4n ps=0.88m w=320 l=100
X7 OUTP CLK VDD VDD pfet_03v3 ad=38.4n pd=0.88m as=38.4n ps=0.88m w=320 l=100
X8 a_n1958_7284# CLK VDD VDD pfet_03v3 ad=19.2n pd=0.56m as=19.2n ps=0.56m w=160 l=100
X9 a_n3030_7284# CLK VDD VDD pfet_03v3 ad=19.2n pd=0.56m as=19.2n ps=0.56m w=160 l=100
X10 a_n3030_7284# INP a_n2018_4466# VSS nfet_03v3 ad=72n pd=1.44m as=72n ps=1.44m w=600 l=140
C0 CLK OUTP 0.0548f
C1 a_n3030_7284# OUTP 0.06964f
C2 a_n1958_7284# VDD 1.57037f
C3 OUTN OUTP 1.56981f
C4 a_n3030_7284# CLK 0.34974f
C5 CLK OUTN 0.06389f
C6 a_n2018_4466# INN 0.12107f
C7 INP CLK 0.01255f
C8 a_n3030_7284# OUTN 0.65952f
C9 VDD OUTP 5.08116f
C10 a_n3030_7284# INP 0.0835f
C11 a_n2018_4466# a_n1958_7284# 0.69589f
C12 a_n1958_7284# INN 0.07888f
C13 VDD CLK 3.74922f
C14 a_n3030_7284# VDD 1.83377f
C15 VDD OUTN 5.11683f
C16 a_n2018_4466# OUTP 0.01623f
C17 a_n2018_4466# CLK 0.30572f
C18 a_n1958_7284# OUTP 0.87207f
C19 a_n2018_4466# a_n3030_7284# 1.50153f
C20 a_n1958_7284# CLK 0.31745f
C21 a_n2018_4466# INP 0.13405f
C22 a_n1958_7284# a_n3030_7284# 0.74082f
C23 a_n1958_7284# OUTN 0.31294f
C24 INP VSS 0.52584f
C25 INN VSS 0.53646f
C26 OUTP VSS 2.67964f
C27 OUTN VSS 3.21618f
C28 CLK VSS 3.74474f
C29 VDD VSS 31.1303f
C30 a_n2018_4466# VSS 6.5166f ; **FLOATING
C31 a_n1958_7284# VSS 3.13096f ; **FLOATING
C32 a_n3030_7284# VSS 2.47453f ; **FLOATING
.ends
