.include '/home/huda/.volare/gf180mcuD/libs.tech/ngspice/design.ngspice'
.lib '/home/huda/.volare/gf180mcuD/libs.tech/ngspice/sm141064.ngspice' typical

* PEX produced on Sun Aug 23 03:49:35 PM CST 2026 using /home/huda/opensource-project/Microelectronic-Block-Generator/designs/notebooks/chipathon2026-D/scripts/iic-pex.sh with m=2 and s=1
* NGSPICE file created from strongarm_comparator.ext - technology: gf180mcuD

.option scale=5n

.subckt strongarm_comparator OUTN OUTP CLK INN INP VSS VDD
X0 OUTP OUTN VDD VDD pfet_03v3 ad=72n pd=1.44m as=72n ps=1.44m w=600 l=100
X1 a_n2018_4466# CLK VSS VSS nfet_03v3 ad=0.2184u pd=3.88m as=0.2184u ps=3.88m w=1820 l=100
X2 OUTN OUTP VDD VDD pfet_03v3 ad=72n pd=1.44m as=72n ps=1.44m w=600 l=100
X3 a_n1958_7284# INN a_n2018_4466# VSS nfet_03v3 ad=72n pd=1.44m as=72n ps=1.44m w=600 l=140
X4 OUTP OUTN a_n1958_7284# VSS nfet_03v3 ad=55.2n pd=1.16m as=55.2n ps=1.16m w=460 l=100
X5 OUTN OUTP a_n3030_7284# VSS nfet_03v3 ad=55.2n pd=1.16m as=55.2n ps=1.16m w=460 l=100
X6 OUTN CLK VDD VDD pfet_03v3 ad=38.4n pd=0.88m as=38.4n ps=0.88m w=320 l=100
X7 OUTP CLK VDD VDD pfet_03v3 ad=38.4n pd=0.88m as=38.4n ps=0.88m w=320 l=100
X8 a_n1958_7284# CLK VDD VDD pfet_03v3 ad=19.2n pd=0.56m as=19.2n ps=0.56m w=160 l=100
X9 a_n3030_7284# CLK VDD VDD pfet_03v3 ad=19.2n pd=0.56m as=19.2n ps=0.56m w=160 l=100
X10 a_n3030_7284# INP a_n2018_4466# VSS nfet_03v3 ad=72n pd=1.44m as=72n ps=1.44m w=600 l=140
C0 VDD OUTP 5.08116f
C1 a_n3030_7284# INP 0.0835f
C2 a_n2018_4466# a_n1958_7284# 0.69589f
C3 a_n1958_7284# INN 0.07888f
C4 VDD CLK 3.74922f
C5 a_n3030_7284# VDD 1.83377f
C6 VDD OUTN 5.11683f
C7 a_n2018_4466# OUTP 0.01623f
C8 a_n2018_4466# CLK 0.30572f
C9 a_n1958_7284# OUTP 0.87207f
C10 a_n2018_4466# a_n3030_7284# 1.50153f
C11 a_n1958_7284# CLK 0.31745f
C12 a_n2018_4466# INP 0.13405f
C13 a_n1958_7284# a_n3030_7284# 0.74082f
C14 a_n1958_7284# OUTN 0.31294f
C15 CLK OUTP 0.0548f
C16 a_n3030_7284# OUTP 0.06964f
C17 a_n1958_7284# VDD 1.57037f
C18 OUTN OUTP 1.56981f
C19 a_n3030_7284# CLK 0.34974f
C20 CLK OUTN 0.06389f
C21 a_n2018_4466# INN 0.12107f
C22 a_n3030_7284# OUTN 0.65952f
C23 INP CLK 0.01255f
C24 INP VSS 0.52584f
C25 INN VSS 0.53646f
C26 OUTP VSS 2.67964f
C27 OUTN VSS 3.21618f
C28 CLK VSS 3.74474f
C29 VDD VSS 31.1303f
C30 a_n2018_4466# VSS 6.5166f ; **FLOATING
C31 a_n1958_7284# VSS 3.13096f ; **FLOATING
C32 a_n3030_7284# VSS 2.47453f ; **FLOATING
.ends

Vsupply0 VDD 0 3.3
Vsupply1 VSS 0 0.0
Vsrc0 CLK 0 PULSE(0 3.3 30n 100p 100p 40n 100n)
Vsrc1 INP 0 PWL(0.000000u 1.652500 0.104000u 1.652500 0.105000u 1.647500 0.204000u 1.647500 0.205000u 1.655000 0.304000u 1.655000 0.305000u 1.645000 0.404000u 1.645000 0.405000u 1.662500 0.504000u 1.662500 0.505000u 1.637500 0.604000u 1.637500 0.605000u 1.675000 0.704000u 1.675000 0.705000u 1.625000 0.804000u 1.625000 0.805000u 1.700000 0.904000u 1.700000 0.905000u 1.600000 1.004000u 1.600000 1.005000u 1.002500 1.104000u 1.002500 1.105000u 0.997500 1.204000u 0.997500 1.205000u 1.050000 1.304000u 1.050000 1.305000u 0.950000 1.404000u 0.950000 1.405000u 2.302500 1.504000u 2.302500 1.505000u 2.297500 1.604000u 2.297500 1.605000u 2.350000 1.704000u 2.350000 1.705000u 2.250000 1.870000u 2.250000)
Vsrc2 INN 0 PWL(0.000000u 1.647500 0.104000u 1.647500 0.105000u 1.652500 0.204000u 1.652500 0.205000u 1.645000 0.304000u 1.645000 0.305000u 1.655000 0.404000u 1.655000 0.405000u 1.637500 0.504000u 1.637500 0.505000u 1.662500 0.604000u 1.662500 0.605000u 1.625000 0.704000u 1.625000 0.705000u 1.675000 0.804000u 1.675000 0.805000u 1.600000 0.904000u 1.600000 0.905000u 1.700000 1.004000u 1.700000 1.005000u 0.997500 1.104000u 0.997500 1.105000u 1.002500 1.204000u 1.002500 1.205000u 0.950000 1.304000u 0.950000 1.305000u 1.050000 1.404000u 1.050000 1.405000u 2.297500 1.504000u 2.297500 1.505000u 2.302500 1.604000u 2.302500 1.605000u 2.250000 1.704000u 2.250000 1.705000u 2.350000 1.870000u 2.350000)
C_load_OUTP OUTP 0 20f
C_load_OUTN OUTN 0 20f
Xdut OUTN OUTP CLK INN INP VSS VDD strongarm_comparator

.control
option reltol=1e-2 trtol=2
tran 20p 1.8750u
wrdata tran.dat v(OUTP) v(OUTN) i(Vsupply0)
.endc
.end
