* PEX produced on Thu Aug 27 11:23:05 AM CST 2026 using /home/huda/opensource-project/Microelectronic-Block-Generator/designs/notebooks/chipathon2026-D/scripts/iic-pex.sh with m=2 and s=1
* NGSPICE file created from strongarm_comparator.ext - technology: gf180mcuD

.option scale=5n

.subckt strongarm_comparator OUTN OUTP CLK INN INP VSS VDD
X0 OUTP CLK VDD VDD pfet_03v3 ad=38.4n pd=0.88m as=38.4n ps=0.88m w=320 l=100
X1 OUTN OUTP VDD VDD pfet_03v3 ad=72n pd=1.44m as=72n ps=1.44m w=600 l=100
X2 a_n2008_7284# CLK VDD VDD pfet_03v3 ad=19.2n pd=0.56m as=19.2n ps=0.56m w=160 l=100
X3 a_n3180_7284# CLK VDD VDD pfet_03v3 ad=19.2n pd=0.56m as=19.2n ps=0.56m w=160 l=100
X4 a_n2018_4466# CLK VSS VSS nfet_03v3 ad=0.2184u pd=3.88m as=0.2184u ps=3.88m w=1820 l=100
X5 OUTP OUTN VDD VDD pfet_03v3 ad=72n pd=1.44m as=72n ps=1.44m w=600 l=100
X6 a_n2008_7284# INN a_n2018_4466# VSS nfet_03v3 ad=72n pd=1.44m as=72n ps=1.44m w=600 l=140
X7 OUTP OUTN a_n2008_7284# VSS nfet_03v3 ad=55.2n pd=1.16m as=55.2n ps=1.16m w=460 l=100
X8 OUTN OUTP a_n3180_7284# VSS nfet_03v3 ad=55.2n pd=1.16m as=55.2n ps=1.16m w=460 l=100
X9 OUTN CLK VDD VDD pfet_03v3 ad=38.4n pd=0.88m as=38.4n ps=0.88m w=320 l=100
X10 a_n3180_7284# INP a_n2018_4466# VSS nfet_03v3 ad=72n pd=1.44m as=72n ps=1.44m w=600 l=140
C0 a_n2008_7284# CLK 0.29164f
C1 a_n2018_4466# INP 0.13252f
C2 a_n2008_7284# a_n3180_7284# 0.73046f
C3 a_n2008_7284# OUTN 0.23079f
C4 CLK OUTP 0.11894f
C5 a_n3180_7284# OUTP 0.17176f
C6 a_n2008_7284# VDD 1.68981f
C7 OUTN OUTP 2.43698f
C8 a_n3180_7284# CLK 0.25661f
C9 CLK OUTN 0.1727f
C10 a_n2018_4466# INN 0.12147f
C11 a_n3180_7284# OUTN 0.63663f
C12 VDD OUTP 5.17741f
C13 a_n3180_7284# INP 0.08197f
C14 a_n2018_4466# a_n2008_7284# 1.00181f
C15 a_n2008_7284# INN 0.09393f
C16 VDD CLK 3.56575f
C17 a_n3180_7284# VDD 1.7739f
C18 VDD OUTN 4.98631f
C19 a_n2018_4466# OUTP 0.04836f
C20 a_n2018_4466# CLK 0.49113f
C21 a_n2008_7284# OUTP 0.74284f
C22 a_n2018_4466# a_n3180_7284# 1.05329f
C23 INP VSS 0.52588f
C24 INN VSS 0.53703f
C25 OUTP VSS 3.20088f
C26 OUTN VSS 3.0075f
C27 CLK VSS 3.51484f
C28 VDD VSS 31.0079f
C29 a_n2018_4466# VSS 6.25309f ; **FLOATING
C30 a_n2008_7284# VSS 3.37381f ; **FLOATING
C31 a_n3180_7284# VSS 2.87736f ; **FLOATING
.ends
