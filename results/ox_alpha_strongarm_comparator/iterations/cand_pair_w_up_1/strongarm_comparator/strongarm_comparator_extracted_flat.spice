* NGSPICE file created from strongarm_comparator.ext - technology: gf180mcuD

.subckt strongarm_comparator VDD VSS INP INN CLK OUTP OUTN
X0 a_n1958_7016# INN a_n2018_4048# VSS nfet_03v3 ad=2.25p pd=8.7u as=2.25p ps=8.7u w=3.75u l=0.7u
X1 OUTN CLK VDD VDD pfet_03v3 ad=0.96p pd=4.4u as=0.96p ps=4.4u w=1.6u l=0.5u
X2 OUTP CLK VDD VDD pfet_03v3 ad=0.96p pd=4.4u as=0.96p ps=4.4u w=1.6u l=0.5u
X3 a_n2018_4048# CLK VSS VSS nfet_03v3 ad=4.2p pd=15.2u as=4.2p ps=15.2u w=7u l=0.5u
X4 a_n1958_7016# CLK VDD VDD pfet_03v3 ad=0.48p pd=2.8u as=0.48p ps=2.8u w=0.8u l=0.5u
X5 a_n3030_7016# CLK VDD VDD pfet_03v3 ad=0.48p pd=2.8u as=0.48p ps=2.8u w=0.8u l=0.5u
X6 OUTP OUTN a_n1958_7016# VSS nfet_03v3 ad=1.2p pd=5.2u as=1.2p ps=5.2u w=2u l=0.5u
X7 OUTN OUTP a_n3030_7016# VSS nfet_03v3 ad=1.2p pd=5.2u as=1.2p ps=5.2u w=2u l=0.5u
X8 a_n3030_7016# INP a_n2018_4048# VSS nfet_03v3 ad=2.25p pd=8.7u as=2.25p ps=8.7u w=3.75u l=0.7u
X9 OUTP OUTN VDD VDD pfet_03v3 ad=1.8p pd=7.2u as=1.8p ps=7.2u w=3u l=0.5u
X10 OUTN OUTP VDD VDD pfet_03v3 ad=1.8p pd=7.2u as=1.8p ps=7.2u w=3u l=0.5u
.ends
