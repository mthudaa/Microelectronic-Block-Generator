* PEX produced on Sun Aug 23 03:27:39 PM CST 2026 using /home/huda/opensource-project/Microelectronic-Block-Generator/designs/notebooks/chipathon2026-D/scripts/iic-pex.sh with m=2 and s=1
* NGSPICE file created from strongarm_comparator.ext - technology: gf180mcuD

.option scale=5n

.subckt strongarm_comparator OUTN OUTP CLK INN INP VSS VDD
X0 OUTN OUTP VDD VDD pfet_03v3 ad=72n pd=1.44m as=72n ps=1.44m w=600 l=100
X1 a_n1958_7444# INN a_n2078_4626# VSS nfet_03v3 ad=72n pd=1.44m as=72n ps=1.44m w=600 l=200
X2 OUTP OUTN a_n1958_7444# VSS nfet_03v3 ad=48n pd=1.04m as=48n ps=1.04m w=400 l=100
X3 a_n2078_4626# CLK VSS VSS nfet_03v3 ad=0.23736u pd=4.196m as=0.23736u ps=4.196m w=1978 l=100
X4 OUTN CLK VDD VDD pfet_03v3 ad=38.4n pd=0.88m as=38.4n ps=0.88m w=320 l=100
X5 OUTP CLK VDD VDD pfet_03v3 ad=38.4n pd=0.88m as=38.4n ps=0.88m w=320 l=100
X6 OUTN OUTP a_n3030_7444# VSS nfet_03v3 ad=48n pd=1.04m as=48n ps=1.04m w=400 l=100
X7 a_n1958_7444# CLK VDD VDD pfet_03v3 ad=19.2n pd=0.56m as=19.2n ps=0.56m w=160 l=100
X8 a_n3030_7444# CLK VDD VDD pfet_03v3 ad=19.2n pd=0.56m as=19.2n ps=0.56m w=160 l=100
X9 a_n3030_7444# INP a_n2078_4626# VSS nfet_03v3 ad=72n pd=1.44m as=72n ps=1.44m w=600 l=200
X10 OUTP OUTN VDD VDD pfet_03v3 ad=72n pd=1.44m as=72n ps=1.44m w=600 l=100
C0 a_n2078_4626# INP 0.13399f
C1 a_n1958_7444# a_n3030_7444# 0.74458f
C2 a_n1958_7444# OUTN 0.34137f
C3 a_n1958_7444# INP 0.02125f
C4 CLK OUTP 0.04662f
C5 a_n3030_7444# OUTP 0.08742f
C6 a_n1958_7444# VDD 1.68905f
C7 OUTN OUTP 1.71095f
C8 a_n3030_7444# CLK 0.30887f
C9 CLK OUTN 0.05907f
C10 a_n2078_4626# INN 0.15723f
C11 a_n3030_7444# OUTN 0.55361f
C12 VDD OUTP 5.03508f
C13 a_n3030_7444# INP 0.11658f
C14 a_n2078_4626# a_n1958_7444# 1.21712f
C15 a_n1958_7444# INN 0.12734f
C16 VDD CLK 3.69548f
C17 a_n3030_7444# VDD 1.64558f
C18 VDD OUTN 5.12934f
C19 a_n2078_4626# CLK 0.6165f
C20 CLK INN 0.01478f
C21 a_n1958_7444# OUTP 0.91085f
C22 a_n2078_4626# a_n3030_7444# 1.04741f
C23 a_n1958_7444# CLK 0.56071f
C24 INP VSS 0.64438f
C25 INN VSS 0.65694f
C26 OUTP VSS 3.259f
C27 OUTN VSS 2.97462f
C28 CLK VSS 3.881f
C29 VDD VSS 31.5639f
C30 a_n2078_4626# VSS 6.75128f ; **FLOATING
C31 a_n1958_7444# VSS 2.84628f ; **FLOATING
C32 a_n3030_7444# VSS 2.67385f ; **FLOATING
.ends
