* PEX produced on Sun Aug 23 03:38:30 PM CST 2026 using /home/huda/opensource-project/Microelectronic-Block-Generator/designs/notebooks/chipathon2026-D/scripts/iic-pex.sh with m=2 and s=1
* NGSPICE file created from strongarm_comparator.ext - technology: gf180mcuD

.option scale=5n

.subckt strongarm_comparator OUTN OUTP CLK INN INP VSS VDD
X0 a_n1958_6864# INN a_n1976_4046# VSS nfet_03v3 ad=72n pd=1.44m as=72n ps=1.44m w=600 l=98
X1 OUTP OUTN a_n1958_6864# VSS nfet_03v3 ad=48n pd=1.04m as=48n ps=1.04m w=400 l=100
X2 a_n1976_4046# CLK VSS VSS nfet_03v3 ad=0.168u pd=3.04m as=0.168u ps=3.04m w=1400 l=100
X3 OUTN OUTP VDD VDD pfet_03v3 ad=72n pd=1.44m as=72n ps=1.44m w=600 l=100
X4 OUTN OUTP a_n3030_6864# VSS nfet_03v3 ad=48n pd=1.04m as=48n ps=1.04m w=400 l=100
X5 OUTN CLK VDD VDD pfet_03v3 ad=38.4n pd=0.88m as=38.4n ps=0.88m w=320 l=100
X6 OUTP CLK VDD VDD pfet_03v3 ad=38.4n pd=0.88m as=38.4n ps=0.88m w=320 l=100
X7 a_n1958_6864# CLK VDD VDD pfet_03v3 ad=19.2n pd=0.56m as=19.2n ps=0.56m w=160 l=100
X8 a_n3030_6864# CLK VDD VDD pfet_03v3 ad=19.2n pd=0.56m as=19.2n ps=0.56m w=160 l=100
X9 a_n3030_6864# INP a_n1976_4046# VSS nfet_03v3 ad=72n pd=1.44m as=72n ps=1.44m w=600 l=98
X10 OUTP OUTN VDD VDD pfet_03v3 ad=72n pd=1.44m as=72n ps=1.44m w=600 l=100
C0 CLK OUTP 0.05486f
C1 a_n3030_6864# OUTP 0.10117f
C2 a_n1958_6864# VDD 1.50446f
C3 OUTN OUTP 1.86425f
C4 a_n3030_6864# CLK 0.37091f
C5 CLK OUTN 0.0643f
C6 a_n1976_4046# INN 0.08788f
C7 a_n3030_6864# OUTN 0.5547f
C8 VDD OUTP 4.89555f
C9 a_n3030_6864# INP 0.07148f
C10 a_n1976_4046# a_n1958_6864# 1.11895f
C11 a_n1958_6864# INN 0.06299f
C12 VDD CLK 3.4574f
C13 a_n3030_6864# VDD 1.75205f
C14 VDD OUTN 5.60902f
C15 a_n1976_4046# CLK 0.34417f
C16 a_n1958_6864# OUTP 0.73236f
C17 a_n1976_4046# a_n3030_6864# 1.1045f
C18 a_n1976_4046# OUTN 0.01981f
C19 a_n1958_6864# CLK 0.3035f
C20 a_n1976_4046# INP 0.08992f
C21 a_n1958_6864# a_n3030_6864# 0.34856f
C22 a_n1958_6864# OUTN 0.33816f
C23 INP VSS 0.45383f
C24 INN VSS 0.46312f
C25 OUTP VSS 2.7852f
C26 OUTN VSS 3.09752f
C27 CLK VSS 4.21657f
C28 VDD VSS 31.8964f
C29 a_n1976_4046# VSS 5.80729f ; **FLOATING
C30 a_n1958_6864# VSS 3.57213f ; **FLOATING
C31 a_n3030_6864# VSS 2.81585f ; **FLOATING
.ends
