* NGSPICE file created from strongarm_comparator.ext - technology: gf180mcuD

.subckt strongarm_comparator OUTN OUTP CLK INN INP VSS VDD
X0 OUTP OUTN VDD VDD pfet_03v3 ad=1.8p pd=7.2u as=1.8p ps=7.2u w=3u l=0.5u
X1 a_n2018_4466# CLK VSS VSS nfet_03v3 ad=5.46p pd=19.4u as=5.46p ps=19.4u w=9.1u l=0.5u
X2 OUTN OUTP VDD VDD pfet_03v3 ad=1.8p pd=7.2u as=1.8p ps=7.2u w=3u l=0.5u
X3 a_n1958_7284# INN a_n2018_4466# VSS nfet_03v3 ad=1.8p pd=7.2u as=1.8p ps=7.2u w=3u l=0.7u
X4 OUTP OUTN a_n1958_7284# VSS nfet_03v3 ad=1.38p pd=5.8u as=1.38p ps=5.8u w=2.3u l=0.5u
X5 OUTN OUTP a_n3030_7284# VSS nfet_03v3 ad=1.38p pd=5.8u as=1.38p ps=5.8u w=2.3u l=0.5u
X6 OUTN CLK VDD VDD pfet_03v3 ad=0.96p pd=4.4u as=0.96p ps=4.4u w=1.6u l=0.5u
X7 OUTP CLK VDD VDD pfet_03v3 ad=0.96p pd=4.4u as=0.96p ps=4.4u w=1.6u l=0.5u
X8 a_n1958_7284# CLK VDD VDD pfet_03v3 ad=0.48p pd=2.8u as=0.48p ps=2.8u w=0.8u l=0.5u
X9 a_n3030_7284# CLK VDD VDD pfet_03v3 ad=0.48p pd=2.8u as=0.48p ps=2.8u w=0.8u l=0.5u
X10 a_n3030_7284# INP a_n2018_4466# VSS nfet_03v3 ad=1.8p pd=7.2u as=1.8p ps=7.2u w=3u l=0.7u
.ends
