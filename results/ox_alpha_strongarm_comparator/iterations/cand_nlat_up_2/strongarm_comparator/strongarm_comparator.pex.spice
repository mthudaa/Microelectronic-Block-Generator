* PEX produced on Sun Aug 23 03:40:43 PM CST 2026 using /home/huda/opensource-project/Microelectronic-Block-Generator/designs/notebooks/chipathon2026-D/scripts/iic-pex.sh with m=2 and s=1
* NGSPICE file created from strongarm_comparator.ext - technology: gf180mcuD

.option scale=5n

.subckt strongarm_comparator OUTN OUTP CLK INN INP VSS VDD
X0 OUTP OUTN a_n1958_6864# VSS nfet_03v3 ad=64.8n pd=1.32m as=64.8n ps=1.32m w=540 l=100
X1 OUTN OUTP a_n3030_6864# VSS nfet_03v3 ad=64.8n pd=1.32m as=64.8n ps=1.32m w=540 l=100
X2 a_n2018_4046# CLK VSS VSS nfet_03v3 ad=0.168u pd=3.04m as=0.168u ps=3.04m w=1400 l=100
X3 OUTN OUTP VDD VDD pfet_03v3 ad=72n pd=1.44m as=72n ps=1.44m w=600 l=100
X4 a_n1958_6864# INN a_n2018_4046# VSS nfet_03v3 ad=72n pd=1.44m as=72n ps=1.44m w=600 l=140
X5 OUTN CLK VDD VDD pfet_03v3 ad=38.4n pd=0.88m as=38.4n ps=0.88m w=320 l=100
X6 OUTP CLK VDD VDD pfet_03v3 ad=38.4n pd=0.88m as=38.4n ps=0.88m w=320 l=100
X7 a_n1958_6864# CLK VDD VDD pfet_03v3 ad=19.2n pd=0.56m as=19.2n ps=0.56m w=160 l=100
X8 a_n3030_6864# CLK VDD VDD pfet_03v3 ad=19.2n pd=0.56m as=19.2n ps=0.56m w=160 l=100
X9 a_n3030_6864# INP a_n2018_4046# VSS nfet_03v3 ad=72n pd=1.44m as=72n ps=1.44m w=600 l=140
X10 OUTP OUTN VDD VDD pfet_03v3 ad=72n pd=1.44m as=72n ps=1.44m w=600 l=100
C0 a_n2018_4046# OUTP 0.05436f
C1 a_n2018_4046# CLK 0.45311f
C2 a_n1958_6864# OUTP 0.86124f
C3 a_n2018_4046# a_n3030_6864# 1.17572f
C4 a_n1958_6864# CLK 0.44489f
C5 a_n2018_4046# INP 0.13199f
C6 a_n1958_6864# a_n3030_6864# 0.2445f
C7 a_n1958_6864# OUTN 0.34182f
C8 a_n1958_6864# INP 0.01169f
C9 CLK OUTP 0.06837f
C10 a_n3030_6864# OUTP 0.27149f
C11 a_n1958_6864# VDD 1.48479f
C12 OUTN OUTP 1.18737f
C13 a_n3030_6864# CLK 0.35292f
C14 CLK OUTN 0.23575f
C15 a_n2018_4046# INN 0.1174f
C16 a_n3030_6864# OUTN 0.71623f
C17 INP CLK 0.01079f
C18 VDD OUTP 5.02324f
C19 a_n3030_6864# INP 0.07908f
C20 a_n2018_4046# a_n1958_6864# 0.84544f
C21 a_n1958_6864# INN 0.08207f
C22 VDD CLK 3.64185f
C23 a_n3030_6864# VDD 1.71772f
C24 VDD OUTN 5.35537f
C25 INP VSS 0.53247f
C26 INN VSS 0.54694f
C27 OUTP VSS 2.87923f
C28 OUTN VSS 3.11275f
C29 CLK VSS 3.43445f
C30 VDD VSS 31.6723f
C31 a_n2018_4046# VSS 5.57146f ; **FLOATING
C32 a_n1958_6864# VSS 3.37503f ; **FLOATING
C33 a_n3030_6864# VSS 2.79265f ; **FLOATING
.ends
