* PEX produced on Thu Aug 27 11:15:41 AM CST 2026 using /home/huda/opensource-project/Microelectronic-Block-Generator/designs/notebooks/chipathon2026-D/scripts/iic-pex.sh with m=2 and s=1
* NGSPICE file created from ota.ext - technology: gf180mcuD

.option scale=5n

.subckt ota IBIAS OUT INN INP VSS VDD
X0 VDD a_n1672_5258# OUT VDD pfet_03v3 ad=14.4n pd=0.48m as=6.72n ps=0.232m w=120 l=200
X1 a_n1742_3047# IBIAS VSS VSS nfet_03v3 ad=22.4n pd=0.512m as=22.4n ps=0.512m w=400 l=200
X2 VDD a_n1672_5258# a_n1672_5258# VDD pfet_03v3 ad=6.72n pd=0.232m as=6.72n ps=0.232m w=120 l=200
X3 VSS IBIAS IBIAS VSS nfet_03v3 ad=11.2n pd=0.312m as=11.2n ps=0.312m w=200 l=200
X4 VDD a_n1672_5258# a_n1672_5258# VDD pfet_03v3 ad=14.4n pd=0.48m as=6.72n ps=0.232m w=120 l=200
X5 a_n1742_3047# INN OUT VSS nfet_03v3 ad=24n pd=0.64m as=11.2n ps=0.312m w=200 l=200
X6 a_n1742_3047# INP a_n1672_5258# VSS nfet_03v3 ad=11.2n pd=0.312m as=11.2n ps=0.312m w=200 l=200
X7 a_n1742_3047# INN OUT VSS nfet_03v3 ad=11.2n pd=0.312m as=11.2n ps=0.312m w=200 l=200
X8 OUT a_n1672_5258# VDD VDD pfet_03v3 ad=6.72n pd=0.232m as=14.4n ps=0.48m w=120 l=200
X9 a_n1742_3047# INP a_n1672_5258# VSS nfet_03v3 ad=24n pd=0.64m as=11.2n ps=0.312m w=200 l=200
X10 VSS IBIAS a_n1742_3047# VSS nfet_03v3 ad=22.4n pd=0.512m as=22.4n ps=0.512m w=400 l=200
X11 OUT a_n1672_5258# VDD VDD pfet_03v3 ad=6.72n pd=0.232m as=6.72n ps=0.232m w=120 l=200
X12 a_n1742_3047# IBIAS VSS VSS nfet_03v3 ad=22.4n pd=0.512m as=48n ps=1.04m w=400 l=200
X13 IBIAS IBIAS VSS VSS nfet_03v3 ad=11.2n pd=0.312m as=11.2n ps=0.312m w=200 l=200
X14 a_n1672_5258# a_n1672_5258# VDD VDD pfet_03v3 ad=6.72n pd=0.232m as=6.72n ps=0.232m w=120 l=200
X15 OUT INN a_n1742_3047# VSS nfet_03v3 ad=11.2n pd=0.312m as=11.2n ps=0.312m w=200 l=200
X16 OUT INN a_n1742_3047# VSS nfet_03v3 ad=11.2n pd=0.312m as=24n ps=0.64m w=200 l=200
X17 a_n1672_5258# a_n1672_5258# VDD VDD pfet_03v3 ad=6.72n pd=0.232m as=14.4n ps=0.48m w=120 l=200
X18 VSS IBIAS IBIAS VSS nfet_03v3 ad=24n pd=0.64m as=11.2n ps=0.312m w=200 l=200
X19 VSS IBIAS a_n1742_3047# VSS nfet_03v3 ad=48n pd=1.04m as=22.4n ps=0.512m w=400 l=200
X20 a_n1672_5258# INP a_n1742_3047# VSS nfet_03v3 ad=11.2n pd=0.312m as=24n ps=0.64m w=200 l=200
X21 a_n1672_5258# INP a_n1742_3047# VSS nfet_03v3 ad=11.2n pd=0.312m as=11.2n ps=0.312m w=200 l=200
X22 VDD a_n1672_5258# OUT VDD pfet_03v3 ad=6.72n pd=0.232m as=6.72n ps=0.232m w=120 l=200
X23 IBIAS IBIAS VSS VSS nfet_03v3 ad=11.2n pd=0.312m as=24n ps=0.64m w=200 l=200
C0 IBIAS a_n1742_3047# 0.40281f
C1 OUT a_n1672_5258# 0.66332f
C2 a_n1672_5258# INP 0.26955f
C3 a_n1672_5258# a_n1742_3047# 1.38238f
C4 VDD a_n1672_5258# 9.04042f
C5 OUT INN 0.31193f
C6 INN a_n1742_3047# 0.3731f
C7 OUT a_n1742_3047# 1.42699f
C8 INP a_n1742_3047# 0.49049f
C9 OUT VDD 3.29608f
C10 IBIAS VSS 9.95355f
C11 INN VSS 2.60502f
C12 INP VSS 2.60558f
C13 OUT VSS 2.75869f
C14 VDD VSS 18.8772f
C15 a_n1742_3047# VSS 6.64804f ; **FLOATING
C16 a_n1672_5258# VSS 2.36214f ; **FLOATING
.ends
