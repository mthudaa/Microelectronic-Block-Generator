* NGSPICE file created from ota.ext - technology: gf180mcuD

.subckt ota VDD VSS INP INN OUT IBIAS
X0 a_n1742_3047# IBIAS VSS VSS nfet_03v3 ad=0.56p pd=2.56u as=0.56p ps=2.56u w=2u l=1u
X1 OUT a_n1622_5258# VDD VDD pfet_03v3 ad=0.168p pd=1.16u as=0.168p ps=1.16u w=0.6u l=1u
X2 VSS IBIAS IBIAS VSS nfet_03v3 ad=0.28p pd=1.56u as=0.28p ps=1.56u w=1u l=1u
X3 a_n1742_3047# INN OUT VSS nfet_03v3 ad=0.6p pd=3.2u as=0.28p ps=1.56u w=1u l=1u
X4 a_n1742_3047# INP a_n1622_5258# VSS nfet_03v3 ad=0.28p pd=1.56u as=0.28p ps=1.56u w=1u l=1u
X5 OUT a_n1622_5258# VDD VDD pfet_03v3 ad=0.168p pd=1.16u as=0.36p ps=2.4u w=0.6u l=1u
X6 a_n1742_3047# INN OUT VSS nfet_03v3 ad=0.28p pd=1.56u as=0.28p ps=1.56u w=1u l=1u
X7 a_n1622_5258# a_n1622_5258# VDD VDD pfet_03v3 ad=0.168p pd=1.16u as=0.36p ps=2.4u w=0.6u l=1u
X8 a_n1622_5258# a_n1622_5258# VDD VDD pfet_03v3 ad=0.168p pd=1.16u as=0.168p ps=1.16u w=0.6u l=1u
X9 a_n1742_3047# INP a_n1622_5258# VSS nfet_03v3 ad=0.6p pd=3.2u as=0.28p ps=1.56u w=1u l=1u
X10 VSS IBIAS a_n1742_3047# VSS nfet_03v3 ad=0.56p pd=2.56u as=0.56p ps=2.56u w=2u l=1u
X11 VDD a_n1622_5258# OUT VDD pfet_03v3 ad=0.36p pd=2.4u as=0.168p ps=1.16u w=0.6u l=1u
X12 VDD a_n1622_5258# a_n1622_5258# VDD pfet_03v3 ad=0.168p pd=1.16u as=0.168p ps=1.16u w=0.6u l=1u
X13 a_n1742_3047# IBIAS VSS VSS nfet_03v3 ad=0.56p pd=2.56u as=1.2p ps=5.2u w=2u l=1u
X14 IBIAS IBIAS VSS VSS nfet_03v3 ad=0.28p pd=1.56u as=0.28p ps=1.56u w=1u l=1u
X15 VDD a_n1622_5258# OUT VDD pfet_03v3 ad=0.168p pd=1.16u as=0.168p ps=1.16u w=0.6u l=1u
X16 OUT INN a_n1742_3047# VSS nfet_03v3 ad=0.28p pd=1.56u as=0.28p ps=1.56u w=1u l=1u
X17 OUT INN a_n1742_3047# VSS nfet_03v3 ad=0.28p pd=1.56u as=0.6p ps=3.2u w=1u l=1u
X18 VSS IBIAS IBIAS VSS nfet_03v3 ad=0.6p pd=3.2u as=0.28p ps=1.56u w=1u l=1u
X19 VSS IBIAS a_n1742_3047# VSS nfet_03v3 ad=1.2p pd=5.2u as=0.56p ps=2.56u w=2u l=1u
X20 VDD a_n1622_5258# a_n1622_5258# VDD pfet_03v3 ad=0.36p pd=2.4u as=0.168p ps=1.16u w=0.6u l=1u
X21 a_n1622_5258# INP a_n1742_3047# VSS nfet_03v3 ad=0.28p pd=1.56u as=0.6p ps=3.2u w=1u l=1u
X22 a_n1622_5258# INP a_n1742_3047# VSS nfet_03v3 ad=0.28p pd=1.56u as=0.28p ps=1.56u w=1u l=1u
X23 IBIAS IBIAS VSS VSS nfet_03v3 ad=0.28p pd=1.56u as=0.6p ps=3.2u w=1u l=1u
.ends
