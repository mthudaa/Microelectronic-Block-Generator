* NGSPICE file created from vref_cmos_1v2.ext - technology: gf180mcuD

.subckt vref_cmos_1v2 IBIAS VREF VSS VDD
X0 a_n4072_2838# IBIAS VSS VSS nfet_03v3 ad=0.56p pd=2.56u as=1.2p ps=5.2u w=2u l=2u
X1 IBIAS IBIAS VSS VSS nfet_03v3 ad=0.56p pd=2.56u as=1.2p ps=5.2u w=2u l=2u
X2 a_n4072_2838# a_n4072_2838# VDD VDD pfet_03v3 ad=1.12p pd=4.56u as=2.4p ps=9.2u w=4u l=4u
X3 VREF a_n4072_2838# VDD VDD pfet_03v3 ad=1.12p pd=4.56u as=1.12p ps=4.56u w=4u l=4u
X4 a_n4072_2838# a_n4072_2838# VDD VDD pfet_03v3 ad=1.12p pd=4.56u as=1.12p ps=4.56u w=4u l=4u
X5 VDD a_n4072_2838# VREF VDD pfet_03v3 ad=2.4p pd=9.2u as=1.12p ps=4.56u w=4u l=4u
X6 VREF VREF VSS VSS nfet_03v3 ad=0.3p pd=2.2u as=0.3p ps=2.2u w=0.5u l=0.4u
X7 VDD a_n4072_2838# a_n4072_2838# VDD pfet_03v3 ad=1.12p pd=4.56u as=1.12p ps=4.56u w=4u l=4u
X8 VDD a_n4072_2838# VREF VDD pfet_03v3 ad=1.12p pd=4.56u as=1.12p ps=4.56u w=4u l=4u
X9 VREF a_n4072_2838# VDD VDD pfet_03v3 ad=1.12p pd=4.56u as=2.4p ps=9.2u w=4u l=4u
X10 VSS IBIAS a_n4072_2838# VSS nfet_03v3 ad=1.2p pd=5.2u as=0.56p ps=2.56u w=2u l=2u
X11 VSS IBIAS IBIAS VSS nfet_03v3 ad=1.2p pd=5.2u as=0.56p ps=2.56u w=2u l=2u
X12 VDD a_n4072_2838# a_n4072_2838# VDD pfet_03v3 ad=2.4p pd=9.2u as=1.12p ps=4.56u w=4u l=4u
.ends
