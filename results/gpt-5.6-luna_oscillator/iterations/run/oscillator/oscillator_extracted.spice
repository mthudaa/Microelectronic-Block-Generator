* NGSPICE file created from oscillator.ext - technology: gf180mcuD

.subckt oscillator OSC_OUT VSS VDD
X0 OSC_OUT a_2122_428# VDD VDD pfet_03v3 ad=2.4p pd=9.2u as=2.4p ps=9.2u w=4u l=2.5u
X1 a_n3494_428# OSC_OUT VDD VDD pfet_03v3 ad=2.4p pd=9.2u as=2.4p ps=9.2u w=4u l=2.5u
X2 a_250_428# a_n1622_428# VDD VDD pfet_03v3 ad=2.4p pd=9.2u as=2.4p ps=9.2u w=4u l=2.5u
X3 a_2122_428# a_250_428# VDD VDD pfet_03v3 ad=2.4p pd=9.2u as=2.4p ps=9.2u w=4u l=2.5u
X4 OSC_OUT a_2122_428# VSS VSS nfet_03v3 ad=1.2p pd=5.2u as=1.2p ps=5.2u w=2u l=2.5u
X5 a_n1622_428# a_n3494_428# VDD VDD pfet_03v3 ad=2.4p pd=9.2u as=2.4p ps=9.2u w=4u l=2.5u
X6 a_n3494_428# OSC_OUT VSS VSS nfet_03v3 ad=1.2p pd=5.2u as=1.2p ps=5.2u w=2u l=2.5u
X7 a_250_428# a_n1622_428# VSS VSS nfet_03v3 ad=1.2p pd=5.2u as=1.2p ps=5.2u w=2u l=2.5u
X8 a_n1622_428# a_n3494_428# VSS VSS nfet_03v3 ad=1.2p pd=5.2u as=1.2p ps=5.2u w=2u l=2.5u
X9 a_2122_428# a_250_428# VSS VSS nfet_03v3 ad=1.2p pd=5.2u as=1.2p ps=5.2u w=2u l=2.5u
.ends
