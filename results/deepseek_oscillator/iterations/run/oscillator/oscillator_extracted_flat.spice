* NGSPICE file created from oscillator.ext - technology: gf180mcuD

.subckt oscillator VDD VSS OSC_OUT
X0 a_400_428# a_n1772_428# VSS VSS nfet_03v3 ad=1.2p pd=5.2u as=1.2p ps=5.2u w=2u l=4u
X1 a_n1772_428# OSC_OUT VDD VDD pfet_03v3 ad=2.4p pd=9.2u as=2.4p ps=9.2u w=4u l=4u
X2 OSC_OUT a_400_428# VSS VSS nfet_03v3 ad=1.2p pd=5.2u as=1.2p ps=5.2u w=2u l=4u
X3 a_n1772_428# OSC_OUT VSS VSS nfet_03v3 ad=1.2p pd=5.2u as=1.2p ps=5.2u w=2u l=4u
X4 a_400_428# a_n1772_428# VDD VDD pfet_03v3 ad=2.4p pd=9.2u as=2.4p ps=9.2u w=4u l=4u
X5 OSC_OUT a_400_428# VDD VDD pfet_03v3 ad=2.4p pd=9.2u as=2.4p ps=9.2u w=4u l=4u
.ends
