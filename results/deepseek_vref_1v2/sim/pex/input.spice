.include '/home/huda/.volare/gf180mcuD/libs.tech/ngspice/design.ngspice'
.lib '/home/huda/.volare/gf180mcuD/libs.tech/ngspice/sm141064.ngspice' typical
.temp 27.0

* PEX produced on Sun Aug 23 05:59:01 AM CST 2026 using /home/huda/opensource-project/Microelectronic-Block-Generator/designs/notebooks/chipathon2026-D/scripts/iic-pex.sh with m=2 and s=1
* NGSPICE file created from vref_1v2.ext - technology: gf180mcuD

.option scale=5n

.subckt vref_1v2 IBIAS VREF VSS VDD
X0 VDD a_n1398_2838# VREF VDD pfet_03v3 ad=96n pd=1.84m as=44.8n ps=0.912m w=800 l=400
X1 VREF a_n1398_2838# VDD VDD pfet_03v3 ad=44.8n pd=0.912m as=96n ps=1.84m w=800 l=400
X2 VREF VREF VSS VSS nfet_03v3 ad=28.8n pd=0.72m as=28.8n ps=0.72m w=240 l=100
X3 VSS IBIAS IBIAS VSS nfet_03v3 ad=48n pd=1.04m as=22.4n ps=0.512m w=400 l=400
X4 VDD a_n1398_2838# a_n1398_2838# VDD pfet_03v3 ad=48n pd=1.04m as=22.4n ps=0.512m w=400 l=400
X5 a_n1398_2838# a_n1398_2838# VDD VDD pfet_03v3 ad=22.4n pd=0.512m as=48n ps=1.04m w=400 l=400
X6 a_n1398_2838# IBIAS VSS VSS nfet_03v3 ad=22.4n pd=0.512m as=48n ps=1.04m w=400 l=400
X7 IBIAS IBIAS VSS VSS nfet_03v3 ad=22.4n pd=0.512m as=48n ps=1.04m w=400 l=400
X8 VSS IBIAS a_n1398_2838# VSS nfet_03v3 ad=48n pd=1.04m as=22.4n ps=0.512m w=400 l=400
C0 VREF IBIAS 0.03213f
C1 a_n1398_2838# IBIAS 0.41076f
C2 VDD VREF 2.21373f
C3 VDD a_n1398_2838# 7.7726f
C4 VREF a_n1398_2838# 0.57212f
C5 IBIAS VSS 8.23145f
C6 VREF VSS 3.68002f
C7 VDD VSS 23.2465f
C8 a_n1398_2838# VSS 3.0291f ; **FLOATING
.ends

VDD VDD 0 3.3
VSSV VSS 0 0.0
IIB 0 IBIAS DC 2e-05
CL VREF 0 1e-12

X1 IBIAS VREF VSS VDD vref_1v2
.control
op
print v(VREF)
print i(VDD) i(VSSV)
set wr_singlescale
dc temp -40 125 5
wrdata temp.dat v(VREF)
dc VDD 2.7 3.6 0.05
wrdata vdd.dat v(VREF)
dc IIB 8u 32u 1u
wrdata ib.dat v(VREF)
.endc
.end
