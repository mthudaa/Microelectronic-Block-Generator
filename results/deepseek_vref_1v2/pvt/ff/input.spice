.include '/home/huda/.volare/gf180mcuD/libs.tech/ngspice/design.ngspice'
.lib '/home/huda/.volare/gf180mcuD/libs.tech/ngspice/sm141064.ngspice' ff
.temp 125

* 1.2V MOS-only voltage reference, GF180MCU 3.3V, ports VDD VSS VREF IBIAS.
* IBIAS -> diode (XM0) -> mirror (XM0b) -> PMOS diode (XM1) -> output diode
* (XM3). XM3's Vgs IS the reference; sizing tuned for VREF ~ 1.2 V and a
* near-flat temperature coefficient at IBIAS = 20 uA.
.subckt vref_1v2 VDD VSS VREF IBIAS
XM0  IBIAS IBIAS VSS  VSS  nfet_03v3 L=2u W=4u nf=2
XM0b pm   IBIAS VSS  VSS  nfet_03v3 L=2u W=4u nf=2
XM1  pm   pm   VDD  VDD  pfet_03v3 L=2u W=4u nf=2
XM2  vref pm   VDD  VDD  pfet_03v3 L=2u W=8u nf=2
XM3  vref vref VSS  VSS  nfet_03v3 L=0.5u W=1.2u nf=1
.ends

VDD VDD 0 3.3
VSSV VSS 0 0.0
IIB 0 IBIAS DC 2e-05
CL VREF 0 1e-12

X1 VDD VSS VREF IBIAS vref_1v2
.control
op
print v(VREF)
print i(VDD) i(VSSV)
set wr_singlescale
dc temp -40 125 5
wrdata temp.dat v(VREF)
dc VDD 2.7 3.6 0.05
wrdata vdd.dat v(VREF)
dc IIB 8u 32u 1u
wrdata ib.dat v(VREF)
.endc
.end
