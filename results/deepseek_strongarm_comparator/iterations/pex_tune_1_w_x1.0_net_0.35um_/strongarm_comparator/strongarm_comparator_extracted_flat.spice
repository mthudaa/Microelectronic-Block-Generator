* NGSPICE file created from strongarm_comparator.ext - technology: gf180mcuD

.subckt strongarm_comparator VDD VSS INP INN CLK OUTP OUTN
X0 a_n3454_5664# CLK VDD VDD pfet_03v3 ad=1.2p pd=5.2u as=1.2p ps=5.2u w=2u l=0.5u
X1 OUTP OUTN VDD VDD pfet_03v3 ad=1.2p pd=5.2u as=0.56p ps=2.56u w=2u l=0.5u
X2 OUTN OUTP a_n3454_5664# VSS nfet_03v3 ad=0.56p pd=2.56u as=1.2p ps=5.2u w=2u l=0.5u
X3 VDD OUTP OUTN VDD pfet_03v3 ad=0.56p pd=2.56u as=0.56p ps=2.56u w=2u l=0.5u
X4 VSS CLK a_n3638_3046# VSS nfet_03v3 ad=0.56p pd=2.56u as=0.56p ps=2.56u w=2u l=0.5u
X5 a_n3638_3046# CLK VSS VSS nfet_03v3 ad=1.2p pd=5.2u as=0.56p ps=2.56u w=2u l=0.5u
X6 VDD OUTN OUTP VDD pfet_03v3 ad=0.56p pd=2.56u as=0.56p ps=2.56u w=2u l=0.5u
X7 a_n3454_5664# INP a_n3638_3046# VSS nfet_03v3 ad=0.56p pd=2.56u as=1.2p ps=5.2u w=2u l=1u
X8 a_n3454_5664# INP a_n3638_3046# VSS nfet_03v3 ad=0.56p pd=2.56u as=0.56p ps=2.56u w=2u l=1u
X9 OUTP OUTN a_n2382_5664# VSS nfet_03v3 ad=1.2p pd=5.2u as=0.56p ps=2.56u w=2u l=0.5u
X10 OUTN CLK VDD VDD pfet_03v3 ad=1.2p pd=5.2u as=1.2p ps=5.2u w=2u l=0.5u
X11 a_n3638_3046# INN a_n2382_5664# VSS nfet_03v3 ad=0.56p pd=2.56u as=0.56p ps=2.56u w=2u l=1u
X12 a_n3638_3046# INN a_n2382_5664# VSS nfet_03v3 ad=1.2p pd=5.2u as=0.56p ps=2.56u w=2u l=1u
X13 OUTN OUTP VDD VDD pfet_03v3 ad=0.56p pd=2.56u as=1.2p ps=5.2u w=2u l=0.5u
X14 OUTN OUTP a_n3454_5664# VSS nfet_03v3 ad=1.2p pd=5.2u as=0.56p ps=2.56u w=2u l=0.5u
X15 a_n2382_5664# INN a_n3638_3046# VSS nfet_03v3 ad=0.56p pd=2.56u as=1.2p ps=5.2u w=2u l=1u
X16 OUTP OUTN VDD VDD pfet_03v3 ad=0.56p pd=2.56u as=1.2p ps=5.2u w=2u l=0.5u
X17 OUTP CLK VDD VDD pfet_03v3 ad=1.2p pd=5.2u as=1.2p ps=5.2u w=2u l=0.5u
X18 a_n2382_5664# OUTN OUTP VSS nfet_03v3 ad=0.56p pd=2.56u as=0.56p ps=2.56u w=2u l=0.5u
X19 a_n3454_5664# OUTP OUTN VSS nfet_03v3 ad=0.56p pd=2.56u as=0.56p ps=2.56u w=2u l=0.5u
X20 a_n2382_5664# INN a_n3638_3046# VSS nfet_03v3 ad=0.56p pd=2.56u as=0.56p ps=2.56u w=2u l=1u
X21 OUTP OUTN a_n2382_5664# VSS nfet_03v3 ad=0.56p pd=2.56u as=1.2p ps=5.2u w=2u l=0.5u
X22 a_n3638_3046# CLK VSS VSS nfet_03v3 ad=0.56p pd=2.56u as=1.2p ps=5.2u w=2u l=0.5u
X23 a_n3638_3046# INP a_n3454_5664# VSS nfet_03v3 ad=1.2p pd=5.2u as=0.56p ps=2.56u w=2u l=1u
X24 OUTN OUTP VDD VDD pfet_03v3 ad=1.2p pd=5.2u as=0.56p ps=2.56u w=2u l=0.5u
X25 a_n3638_3046# INP a_n3454_5664# VSS nfet_03v3 ad=0.56p pd=2.56u as=0.56p ps=2.56u w=2u l=1u
X26 a_n2382_5664# CLK VDD VDD pfet_03v3 ad=1.2p pd=5.2u as=1.2p ps=5.2u w=2u l=0.5u
.ends
