* NGSPICE file created from strongarm_comparator.ext - technology: gf180mcuD

.subckt strongarm_comparator VDD VSS INP INN CLK OUTP OUTN
X0 a_n2382_5792# CLK VDD VDD pfet_03v3 ad=1.38p pd=5.8u as=1.38p ps=5.8u w=2.3u l=0.5u
X1 VDD OUTN OUTP VDD pfet_03v3 ad=0.6468p pd=2.87u as=0.6468p ps=2.87u w=2.31u l=0.5u
X2 a_n3454_5792# CLK VDD VDD pfet_03v3 ad=1.38p pd=5.8u as=1.38p ps=5.8u w=2.3u l=0.5u
X3 a_n3454_5792# OUTP OUTN VSS nfet_03v3 ad=0.6468p pd=2.87u as=0.6468p ps=2.87u w=2.31u l=0.5u
X4 OUTP OUTN a_n2382_5792# VSS nfet_03v3 ad=0.6468p pd=2.87u as=1.386p ps=5.82u w=2.31u l=0.5u
X5 a_n2382_5792# INN a_n3638_3110# VSS nfet_03v3 ad=0.644p pd=2.86u as=1.38p ps=5.8u w=2.3u l=1u
X6 VSS CLK a_n3638_3110# VSS nfet_03v3 ad=0.6468p pd=2.87u as=0.6468p ps=2.87u w=2.31u l=0.5u
X7 a_n3638_3110# CLK VSS VSS nfet_03v3 ad=1.386p pd=5.82u as=0.6468p ps=2.87u w=2.31u l=0.5u
X8 OUTN OUTP VDD VDD pfet_03v3 ad=0.6468p pd=2.87u as=1.386p ps=5.82u w=2.31u l=0.5u
X9 OUTP OUTN VDD VDD pfet_03v3 ad=0.6468p pd=2.87u as=1.386p ps=5.82u w=2.31u l=0.5u
X10 OUTN OUTP a_n3454_5792# VSS nfet_03v3 ad=0.6468p pd=2.87u as=1.386p ps=5.82u w=2.31u l=0.5u
X11 a_n2382_5792# INN a_n3638_3110# VSS nfet_03v3 ad=0.644p pd=2.86u as=0.644p ps=2.86u w=2.3u l=1u
X12 OUTN CLK VDD VDD pfet_03v3 ad=1.38p pd=5.8u as=1.38p ps=5.8u w=2.3u l=0.5u
X13 a_n3638_3110# INP a_n3454_5792# VSS nfet_03v3 ad=0.644p pd=2.86u as=0.644p ps=2.86u w=2.3u l=1u
X14 a_n3638_3110# INP a_n3454_5792# VSS nfet_03v3 ad=1.38p pd=5.8u as=0.644p ps=2.86u w=2.3u l=1u
X15 OUTP OUTN a_n2382_5792# VSS nfet_03v3 ad=1.386p pd=5.82u as=0.6468p ps=2.87u w=2.31u l=0.5u
X16 OUTN OUTP VDD VDD pfet_03v3 ad=1.386p pd=5.82u as=0.6468p ps=2.87u w=2.31u l=0.5u
X17 OUTP CLK VDD VDD pfet_03v3 ad=1.38p pd=5.8u as=1.38p ps=5.8u w=2.3u l=0.5u
X18 OUTP OUTN VDD VDD pfet_03v3 ad=1.386p pd=5.82u as=0.6468p ps=2.87u w=2.31u l=0.5u
X19 OUTN OUTP a_n3454_5792# VSS nfet_03v3 ad=1.386p pd=5.82u as=0.6468p ps=2.87u w=2.31u l=0.5u
X20 a_n3638_3110# CLK VSS VSS nfet_03v3 ad=0.6468p pd=2.87u as=1.386p ps=5.82u w=2.31u l=0.5u
X21 a_n2382_5792# OUTN OUTP VSS nfet_03v3 ad=0.6468p pd=2.87u as=0.6468p ps=2.87u w=2.31u l=0.5u
X22 a_n3454_5792# INP a_n3638_3110# VSS nfet_03v3 ad=0.644p pd=2.86u as=1.38p ps=5.8u w=2.3u l=1u
X23 a_n3454_5792# INP a_n3638_3110# VSS nfet_03v3 ad=0.644p pd=2.86u as=0.644p ps=2.86u w=2.3u l=1u
X24 a_n3638_3110# INN a_n2382_5792# VSS nfet_03v3 ad=0.644p pd=2.86u as=0.644p ps=2.86u w=2.3u l=1u
X25 VDD OUTP OUTN VDD pfet_03v3 ad=0.6468p pd=2.87u as=0.6468p ps=2.87u w=2.31u l=0.5u
X26 a_n3638_3110# INN a_n2382_5792# VSS nfet_03v3 ad=1.38p pd=5.8u as=0.644p ps=2.86u w=2.3u l=1u
.ends
