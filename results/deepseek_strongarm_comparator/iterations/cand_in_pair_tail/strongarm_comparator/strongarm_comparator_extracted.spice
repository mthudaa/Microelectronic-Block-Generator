* NGSPICE file created from strongarm_comparator.ext - technology: gf180mcuD

.subckt strongarm_comparator OUTN OUTP CLK INN INP VSS VDD
X0 a_n3550_3126# INN a_n2382_5744# VSS nfet_03v3 ad=0.56p pd=2.56u as=0.56p ps=2.56u w=2u l=0.6u
X1 VSS CLK a_n3550_3126# VSS nfet_03v3 ad=1.44p pd=6u as=0.672p ps=2.96u w=2.4u l=0.5u
X2 a_n3454_5744# INP a_n3550_3126# VSS nfet_03v3 ad=0.56p pd=2.56u as=1.2p ps=5.2u w=2u l=0.6u
X3 VSS CLK a_n3550_3126# VSS nfet_03v3 ad=0.672p pd=2.96u as=0.672p ps=2.96u w=2.4u l=0.5u
X4 OUTN OUTP VDD VDD pfet_03v3 ad=1.2p pd=5.2u as=0.56p ps=2.56u w=2u l=0.5u
X5 a_n2382_5744# CLK VDD VDD pfet_03v3 ad=1.2p pd=5.2u as=1.2p ps=5.2u w=2u l=0.5u
X6 a_n3550_3126# INP a_n3454_5744# VSS nfet_03v3 ad=0.56p pd=2.56u as=0.56p ps=2.56u w=2u l=0.6u
X7 OUTN OUTP a_n3454_5744# VSS nfet_03v3 ad=1.2p pd=5.2u as=0.56p ps=2.56u w=2u l=0.5u
X8 OUTP OUTN VDD VDD pfet_03v3 ad=1.2p pd=5.2u as=0.56p ps=2.56u w=2u l=0.5u
X9 a_n3454_5744# CLK VDD VDD pfet_03v3 ad=1.2p pd=5.2u as=1.2p ps=5.2u w=2u l=0.5u
X10 OUTP OUTN a_n2382_5744# VSS nfet_03v3 ad=0.56p pd=2.56u as=1.2p ps=5.2u w=2u l=0.5u
X11 OUTP OUTN a_n2382_5744# VSS nfet_03v3 ad=1.2p pd=5.2u as=0.56p ps=2.56u w=2u l=0.5u
X12 a_n2382_5744# OUTN OUTP VSS nfet_03v3 ad=0.56p pd=2.56u as=0.56p ps=2.56u w=2u l=0.5u
X13 VDD OUTP OUTN VDD pfet_03v3 ad=0.56p pd=2.56u as=0.56p ps=2.56u w=2u l=0.5u
X14 a_n3454_5744# OUTP OUTN VSS nfet_03v3 ad=0.56p pd=2.56u as=0.56p ps=2.56u w=2u l=0.5u
X15 VDD OUTN OUTP VDD pfet_03v3 ad=0.56p pd=2.56u as=0.56p ps=2.56u w=2u l=0.5u
X16 a_n3454_5744# INP a_n3550_3126# VSS nfet_03v3 ad=1.2p pd=5.2u as=0.56p ps=2.56u w=2u l=0.6u
X17 a_n3550_3126# CLK VSS VSS nfet_03v3 ad=0.672p pd=2.96u as=1.44p ps=6u w=2.4u l=0.5u
X18 OUTN CLK VDD VDD pfet_03v3 ad=1.2p pd=5.2u as=1.2p ps=5.2u w=2u l=0.5u
X19 a_n3550_3126# INP a_n3454_5744# VSS nfet_03v3 ad=0.56p pd=2.56u as=0.56p ps=2.56u w=2u l=0.6u
X20 a_n3550_3126# INN a_n2382_5744# VSS nfet_03v3 ad=0.56p pd=2.56u as=0.56p ps=2.56u w=2u l=0.6u
X21 a_n3454_5744# INP a_n3550_3126# VSS nfet_03v3 ad=0.56p pd=2.56u as=0.56p ps=2.56u w=2u l=0.6u
X22 OUTN OUTP VDD VDD pfet_03v3 ad=0.56p pd=2.56u as=1.2p ps=5.2u w=2u l=0.5u
X23 a_n2382_5744# INN a_n3550_3126# VSS nfet_03v3 ad=0.56p pd=2.56u as=0.56p ps=2.56u w=2u l=0.6u
X24 OUTN OUTP a_n3454_5744# VSS nfet_03v3 ad=0.56p pd=2.56u as=1.2p ps=5.2u w=2u l=0.5u
X25 OUTP OUTN VDD VDD pfet_03v3 ad=0.56p pd=2.56u as=1.2p ps=5.2u w=2u l=0.5u
X26 a_n2382_5744# INN a_n3550_3126# VSS nfet_03v3 ad=0.56p pd=2.56u as=1.2p ps=5.2u w=2u l=0.6u
X27 a_n3550_3126# CLK VSS VSS nfet_03v3 ad=0.672p pd=2.96u as=0.672p ps=2.96u w=2.4u l=0.5u
X28 OUTP CLK VDD VDD pfet_03v3 ad=1.2p pd=5.2u as=1.2p ps=5.2u w=2u l=0.5u
X29 a_n2382_5744# INN a_n3550_3126# VSS nfet_03v3 ad=1.2p pd=5.2u as=0.56p ps=2.56u w=2u l=0.6u
.ends
