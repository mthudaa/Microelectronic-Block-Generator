.include '/home/huda/.volare/gf180mcuD/libs.tech/ngspice/design.ngspice'
.lib '/home/huda/.volare/gf180mcuD/libs.tech/ngspice/sm141064.ngspice' typical
.temp 27.0
* PEX produced on Sun Aug 23 11:35:25 AM CST 2026 using /home/huda/opensource-project/Microelectronic-Block-Generator/designs/notebooks/chipathon2026-D/scripts/iic-pex.sh with m=2 and s=1
* NGSPICE file created from strongarm_comparator.ext - technology: gf180mcuD

.option scale=5n

.subckt strongarm_comparator OUTN OUTP CLK INN INP VSS VDD
X0 OUTP OUTN VDD VDD pfet_03v3 ad=48n pd=1.04m as=22.4n ps=0.512m w=400 l=100
X1 VSS CLK a_n268_428# VSS nfet_03v3 ad=48n pd=1.04m as=22.4n ps=0.512m w=400 l=100
X2 a_n1854_3046# CLK VDD VDD pfet_03v3 ad=48n pd=1.04m as=48n ps=1.04m w=400 l=100
X3 a_n1854_3046# INN a_n268_428# VSS nfet_03v3 ad=48n pd=1.04m as=22.4n ps=0.512m w=400 l=120
X4 VSS CLK a_n268_428# VSS nfet_03v3 ad=22.4n pd=0.512m as=22.4n ps=0.512m w=400 l=100
X5 a_n3350_3046# INP a_n268_428# VSS nfet_03v3 ad=48n pd=1.04m as=22.4n ps=0.512m w=400 l=120
X6 OUTN OUTP a_n3350_3046# VSS nfet_03v3 ad=22.4n pd=0.512m as=48n ps=1.04m w=400 l=100
X7 OUTP OUTN VDD VDD pfet_03v3 ad=22.4n pd=0.512m as=48n ps=1.04m w=400 l=100
X8 OUTN CLK VDD VDD pfet_03v3 ad=48n pd=1.04m as=48n ps=1.04m w=400 l=100
X9 OUTN OUTP VDD VDD pfet_03v3 ad=22.4n pd=0.512m as=48n ps=1.04m w=400 l=100
X10 OUTN OUTP VDD VDD pfet_03v3 ad=48n pd=1.04m as=22.4n ps=0.512m w=400 l=100
X11 OUTP CLK VDD VDD pfet_03v3 ad=48n pd=1.04m as=48n ps=1.04m w=400 l=100
X12 OUTP OUTN a_n1854_3046# VSS nfet_03v3 ad=22.4n pd=0.512m as=48n ps=1.04m w=400 l=100
X13 a_n268_428# INN a_n1854_3046# VSS nfet_03v3 ad=22.4n pd=0.512m as=22.4n ps=0.512m w=400 l=120
X14 OUTN OUTP a_n3350_3046# VSS nfet_03v3 ad=48n pd=1.04m as=22.4n ps=0.512m w=400 l=100
X15 a_n3350_3046# OUTP OUTN VSS nfet_03v3 ad=22.4n pd=0.512m as=22.4n ps=0.512m w=400 l=100
X16 a_n1854_3046# INN a_n268_428# VSS nfet_03v3 ad=22.4n pd=0.512m as=22.4n ps=0.512m w=400 l=120
X17 a_n1854_3046# INN a_n268_428# VSS nfet_03v3 ad=22.4n pd=0.512m as=48n ps=1.04m w=400 l=120
X18 a_n268_428# CLK VSS VSS nfet_03v3 ad=22.4n pd=0.512m as=48n ps=1.04m w=400 l=100
X19 a_n268_428# INN a_n1854_3046# VSS nfet_03v3 ad=22.4n pd=0.512m as=22.4n ps=0.512m w=400 l=120
X20 VDD OUTN OUTP VDD pfet_03v3 ad=22.4n pd=0.512m as=22.4n ps=0.512m w=400 l=100
X21 a_n3350_3046# INP a_n268_428# VSS nfet_03v3 ad=22.4n pd=0.512m as=22.4n ps=0.512m w=400 l=120
X22 a_n3350_3046# INP a_n268_428# VSS nfet_03v3 ad=22.4n pd=0.512m as=48n ps=1.04m w=400 l=120
X23 VDD OUTP OUTN VDD pfet_03v3 ad=22.4n pd=0.512m as=22.4n ps=0.512m w=400 l=100
X24 a_n1854_3046# OUTN OUTP VSS nfet_03v3 ad=22.4n pd=0.512m as=22.4n ps=0.512m w=400 l=100
X25 OUTP OUTN a_n1854_3046# VSS nfet_03v3 ad=48n pd=1.04m as=22.4n ps=0.512m w=400 l=100
X26 a_n268_428# INP a_n3350_3046# VSS nfet_03v3 ad=22.4n pd=0.512m as=22.4n ps=0.512m w=400 l=120
X27 a_n3350_3046# CLK VDD VDD pfet_03v3 ad=48n pd=1.04m as=48n ps=1.04m w=400 l=100
X28 a_n268_428# INP a_n3350_3046# VSS nfet_03v3 ad=22.4n pd=0.512m as=22.4n ps=0.512m w=400 l=120
X29 a_n268_428# CLK VSS VSS nfet_03v3 ad=22.4n pd=0.512m as=22.4n ps=0.512m w=400 l=100
C0 a_n268_428# CLK 0.87433f
C1 CLK INP 0.01072f
C2 a_n268_428# OUTP 0.01191f
C3 a_n1854_3046# CLK 0.29921f
C4 a_n268_428# a_n3350_3046# 2.43605f
C5 a_n3350_3046# INP 0.36539f
C6 a_n1854_3046# OUTP 2.05144f
C7 a_n268_428# INN 0.50353f
C8 a_n1854_3046# a_n3350_3046# 0.67458f
C9 a_n1854_3046# OUTN 0.8089f
C10 a_n1854_3046# INN 0.36539f
C11 OUTP CLK 0.66688f
C12 a_n3350_3046# CLK 0.12391f
C13 a_n1854_3046# VDD 1.85627f
C14 OUTN CLK 0.39002f
C15 a_n3350_3046# OUTP 0.53408f
C16 INN CLK 0.01444f
C17 OUTP OUTN 2.81996f
C18 a_n268_428# INP 0.53022f
C19 a_n3350_3046# OUTN 2.42268f
C20 VDD CLK 2.92727f
C21 a_n268_428# a_n1854_3046# 2.77269f
C22 a_n1854_3046# INP 0.01775f
C23 VDD OUTP 8.22282f
C24 a_n3350_3046# VDD 1.66515f
C25 VDD OUTN 7.16843f
C26 INN VSS 2.43148f
C27 INP VSS 2.46372f
C28 CLK VSS 4.17856f
C29 OUTN VSS 4.518f
C30 OUTP VSS 3.68577f
C31 VDD VSS 35.0127f
C32 a_n268_428# VSS 5.91478f ; **FLOATING
C33 a_n1854_3046# VSS 3.48342f ; **FLOATING
C34 a_n3350_3046# VSS 3.52671f ; **FLOATING
.ends
Cdiag_inn a_n1854_3046# 0 2e-15

Vsupply0 VDD 0 DC 3.300000
Vsupply1 VSS 0 DC 0.0
Vsrc0 INP 0 PWL(0 1.6350000 1e-07 1.6375000 2e-07 1.6400000 3e-07 1.6425000 4e-07 1.6450000 5e-07 1.6475000 6e-07 1.6500000 7e-07 1.6525000 8e-07 1.6550000 9e-07 1.6575000 1e-06 1.6600000 1.1e-06 1.6625000 1.2e-06 1.6650000)
Vsrc1 INN 0 PWL(0 1.6650000 1e-07 1.6625000 2e-07 1.6600000 3e-07 1.6575000 4e-07 1.6550000 5e-07 1.6525000 6e-07 1.6500000 7e-07 1.6475000 8e-07 1.6450000 9e-07 1.6425000 1e-06 1.6400000 1.1e-06 1.6375000 1.2e-06 1.6350000)
Vsrc2 CLK 0 PULSE(0 3.300000 2e-08 0.1n 0.1n 5e-08 1e-07)
C_load_OUTP OUTP 0 2e-14
C_load_OUTN OUTN 0 2e-14
Xdut OUTN OUTP CLK INN INP VSS VDD strongarm_comparator

.probe tran i(Vsupply0)
.control
tran 0.5n 1.3e-06
wrdata comb.dat v(OUTP) v(OUTN) v(CLK) i(Vsupply0)
.endc
.end
