* PEX produced on Thu Aug 27 11:16:39 AM CST 2026 using /home/huda/opensource-project/Microelectronic-Block-Generator/designs/notebooks/chipathon2026-D/scripts/iic-pex.sh with m=2 and s=1
* NGSPICE file created from strongarm_comparator.ext - technology: gf180mcuD

.option scale=5n

.subckt strongarm_comparator OUTN OUTP CLK INN INP VSS VDD
X0 OUTN OUTP VDD VDD pfet_03v3 ad=22.4n pd=0.512m as=48n ps=1.04m w=400 l=100
X1 OUTP CLK VDD VDD pfet_03v3 ad=48n pd=1.04m as=48n ps=1.04m w=400 l=100
X2 a_n2550_3046# CLK VDD VDD pfet_03v3 ad=48n pd=1.04m as=48n ps=1.04m w=400 l=100
X3 a_n2550_3046# INN a_n654_3046# VSS nfet_03v3 ad=22.4n pd=0.512m as=22.4n ps=0.512m w=400 l=120
X4 a_n654_3046# INP a_n4046_3046# VSS nfet_03v3 ad=48n pd=1.04m as=22.4n ps=0.512m w=400 l=120
X5 OUTP OUTN VDD VDD pfet_03v3 ad=22.4n pd=0.512m as=48n ps=1.04m w=400 l=100
X6 OUTN CLK VDD VDD pfet_03v3 ad=48n pd=1.04m as=48n ps=1.04m w=400 l=100
X7 OUTN OUTP a_n4046_3046# VSS nfet_03v3 ad=48n pd=1.04m as=22.4n ps=0.512m w=400 l=100
X8 a_n2550_3046# OUTN OUTP VSS nfet_03v3 ad=22.4n pd=0.512m as=22.4n ps=0.512m w=400 l=100
X9 a_n654_3046# INN a_n2550_3046# VSS nfet_03v3 ad=48n pd=1.04m as=22.4n ps=0.512m w=400 l=120
X10 a_n654_3046# INP a_n4046_3046# VSS nfet_03v3 ad=22.4n pd=0.512m as=22.4n ps=0.512m w=400 l=120
X11 a_n654_3046# INN a_n2550_3046# VSS nfet_03v3 ad=22.4n pd=0.512m as=22.4n ps=0.512m w=400 l=120
X12 a_n654_3046# CLK VSS VSS nfet_03v3 ad=48n pd=1.04m as=48n ps=1.04m w=400 l=100
X13 VDD OUTP OUTN VDD pfet_03v3 ad=22.4n pd=0.512m as=22.4n ps=0.512m w=400 l=100
X14 OUTN OUTP VDD VDD pfet_03v3 ad=48n pd=1.04m as=22.4n ps=0.512m w=400 l=100
X15 a_n4046_3046# INP a_n654_3046# VSS nfet_03v3 ad=22.4n pd=0.512m as=48n ps=1.04m w=400 l=120
X16 a_n2550_3046# INN a_n654_3046# VSS nfet_03v3 ad=22.4n pd=0.512m as=22.4n ps=0.512m w=400 l=120
X17 VDD OUTN OUTP VDD pfet_03v3 ad=22.4n pd=0.512m as=22.4n ps=0.512m w=400 l=100
X18 OUTP OUTN a_n2550_3046# VSS nfet_03v3 ad=48n pd=1.04m as=22.4n ps=0.512m w=400 l=100
X19 a_n654_3046# INN a_n2550_3046# VSS nfet_03v3 ad=22.4n pd=0.512m as=22.4n ps=0.512m w=400 l=120
X20 a_n2550_3046# INN a_n654_3046# VSS nfet_03v3 ad=22.4n pd=0.512m as=22.4n ps=0.512m w=400 l=120
X21 OUTN OUTP a_n4046_3046# VSS nfet_03v3 ad=22.4n pd=0.512m as=48n ps=1.04m w=400 l=100
X22 a_n2550_3046# INN a_n654_3046# VSS nfet_03v3 ad=22.4n pd=0.512m as=48n ps=1.04m w=400 l=120
X23 a_n654_3046# INN a_n2550_3046# VSS nfet_03v3 ad=22.4n pd=0.512m as=22.4n ps=0.512m w=400 l=120
X24 a_n654_3046# INP a_n4046_3046# VSS nfet_03v3 ad=22.4n pd=0.512m as=22.4n ps=0.512m w=400 l=120
X25 a_n654_3046# INP a_n4046_3046# VSS nfet_03v3 ad=22.4n pd=0.512m as=22.4n ps=0.512m w=400 l=120
X26 OUTP OUTN VDD VDD pfet_03v3 ad=48n pd=1.04m as=22.4n ps=0.512m w=400 l=100
X27 a_n4046_3046# CLK VDD VDD pfet_03v3 ad=48n pd=1.04m as=48n ps=1.04m w=400 l=100
X28 a_n4046_3046# INP a_n654_3046# VSS nfet_03v3 ad=22.4n pd=0.512m as=22.4n ps=0.512m w=400 l=120
X29 OUTP OUTN a_n2550_3046# VSS nfet_03v3 ad=22.4n pd=0.512m as=48n ps=1.04m w=400 l=100
X30 a_n4046_3046# INP a_n654_3046# VSS nfet_03v3 ad=22.4n pd=0.512m as=22.4n ps=0.512m w=400 l=120
X31 a_n4046_3046# OUTP OUTN VSS nfet_03v3 ad=22.4n pd=0.512m as=22.4n ps=0.512m w=400 l=100
X32 a_n4046_3046# INP a_n654_3046# VSS nfet_03v3 ad=22.4n pd=0.512m as=22.4n ps=0.512m w=400 l=120
C0 a_n2550_3046# VDD 1.74188f
C1 OUTN CLK 0.05446f
C2 a_n4046_3046# OUTP 0.5574f
C3 OUTP OUTN 2.64189f
C4 a_n654_3046# INP 0.75478f
C5 a_n4046_3046# OUTN 2.02404f
C6 VDD CLK 2.95912f
C7 a_n654_3046# a_n2550_3046# 4.17529f
C8 a_n2550_3046# INP 0.02044f
C9 VDD OUTP 8.03375f
C10 a_n4046_3046# VDD 1.80465f
C11 VDD OUTN 9.14528f
C12 a_n654_3046# CLK 0.62639f
C13 CLK INP 0.05595f
C14 a_n654_3046# OUTP 0.02052f
C15 a_n2550_3046# CLK 0.49541f
C16 a_n654_3046# a_n4046_3046# 3.73892f
C17 a_n4046_3046# INP 0.68573f
C18 a_n2550_3046# OUTP 1.86387f
C19 a_n654_3046# INN 0.77966f
C20 a_n2550_3046# a_n4046_3046# 0.93605f
C21 a_n2550_3046# OUTN 0.65529f
C22 a_n2550_3046# INN 0.67531f
C23 OUTP CLK 0.90741f
C24 a_n4046_3046# CLK 0.28267f
C25 INN VSS 3.87088f
C26 INP VSS 4.02714f
C27 CLK VSS 2.68679f
C28 OUTN VSS 3.95041f
C29 OUTP VSS 4.87133f
C30 VDD VSS 36.3487f
C31 a_n654_3046# VSS 6.12564f ; **FLOATING
C32 a_n2550_3046# VSS 3.77542f ; **FLOATING
C33 a_n4046_3046# VSS 4.04667f ; **FLOATING
.ends
