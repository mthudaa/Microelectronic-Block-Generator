.include '/home/huda/.volare/gf180mcuD/libs.tech/ngspice/design.ngspice'
.lib '/home/huda/.volare/gf180mcuD/libs.tech/ngspice/sm141064.ngspice' sf

.subckt vref_1v2 VDD VSS VREF IBIAS
* External IBIAS sinks the PMOS mirror reference current.
XM1 IBIAS IBIAS VDD  VDD  pfet_03v3 L=1.25u W=4u nf=1
XM2 VREF  IBIAS VDD  VDD  pfet_03v3 L=1.25u W=0.6u nf=1
* Two diode-connected NMOS devices establish the MOS-only reference voltage.
XM3 N1    N1    VSS  VSS  nfet_03v3 L=0.28u W=9.9u nf=1
XM4 VREF  VREF  N1   VSS  nfet_03v3 L=0.28u W=9.9u nf=1
.ends vref_1v2

Vsupply0 VDD 0 3.6
Vsupply1 VSS 0 0.0
I_BIAS IBIAS VSS 2e-05
C_LOAD VREF VSS 1p
Xdut VDD VSS VREF IBIAS vref_1v2

.temp 125
.control
op
print v(VREF) i(Vsupply0)
.endc
.end
