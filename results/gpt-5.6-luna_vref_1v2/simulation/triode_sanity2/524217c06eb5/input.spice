.include '/home/huda/.volare/gf180mcuD/libs.tech/ngspice/design.ngspice'
.lib '/home/huda/.volare/gf180mcuD/libs.tech/ngspice/sm141064.ngspice' typical

.subckt vref_1v2 VDD VSS VREF IBIAS
* External IBIAS sinks the PMOS mirror reference current.
XM1 IBIAS IBIAS VDD  VDD  pfet_03v3 L=8u    W=2u   nf=1
XM2 VREF  IBIAS VDD  VDD  pfet_03v3 L=8u    W=2u   nf=1
* XM3 is the CTAT diode-connected device; XM4 adds opposing TC in triode.
XM3 VREF  VREF  VMB  VSS  nfet_03v3 L=0.28u W=9.5u nf=1
XM4 VMB   VREF  VSS  VSS  nfet_03v3 L=8u    W=9.5u nf=1
.ends vref_1v2

Vsupply0 VDD 0 3.3
Vsupply1 VSS 0 0.0
I_BIAS IBIAS VSS 3e-05
C_LOAD VREF VSS 1p
Xdut VDD VSS VREF IBIAS vref_1v2

.temp 27.0
.control
op
print v(VREF) i(Vsupply0)
.endc
.end
