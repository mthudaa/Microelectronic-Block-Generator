* PEX produced on Wed Oct 28 12:57:47 UTC 2026 using <repo>/designs/notebooks/chipathon2026-D/scripts/iic-pex.sh with m=2 and s=1
* NGSPICE file created from vref_bgr_1v2.ext - technology: gf180mcuD

.option scale=5n

.subckt vref_bgr_1v2 IBIAS VREF VSS VDD
X0 a_n6942_14706# a_n6942_14706# VSS VSS nfet_03v3 ad=48n pd=1.04m as=48n ps=1.04m w=400 l=1600
X1 VSS VSS a_n4958_14498# pnp_05p00x05p00
X2 a_n7862_14706# a_n4158_14706# VDD VDD pfet_03v3 ad=48n pd=1.04m as=48n ps=1.04m w=400 l=1600
X3 a_n2020_3936# a_n1060_3936# VSS ppolyf_u_1k r_width=1u r_length=25u
X4 a_n7742_14498# a_n2628_328# VSS ppolyf_u_1k r_width=1u r_length=10u
X5 VSS VSS a_n2628_328# pnp_10p00x10p00
X6 VSS VSS a_1820_3936# pnp_05p00x05p00
X7 a_n4158_14706# IBIAS VSS VSS nfet_03v3 ad=24n pd=0.64m as=24n ps=0.64m w=200 l=400
X8 VREF a_n2020_3936# VSS ppolyf_u_1k r_width=1u r_length=25u
X9 a_860_3936# a_1820_3936# VSS ppolyf_u_1k r_width=1u r_length=25u
X10 a_n7862_14706# a_n4958_14498# a_n4158_14706# VDD pfet_03v3 ad=96n pd=1.84m as=44.8n ps=0.912m w=800 l=800
X11 a_n4158_14706# a_n6942_14706# VSS VSS nfet_03v3 ad=48n pd=1.04m as=48n ps=1.04m w=400 l=1600
X12 IBIAS VREF VSS VSS nfet_03v3 ad=0.192u pd=3.44m as=0.192u ps=3.44m w=1600 l=200
X13 VSS VSS a_n2628_328# pnp_10p00x10p00
X14 a_n4958_14498# a_n4158_14706# VDD VDD pfet_03v3 ad=48n pd=1.04m as=48n ps=1.04m w=400 l=1600
X15 a_n1060_3936# a_860_3936# VSS ppolyf_u_1k r_width=1u r_length=25u
X16 a_n7742_14498# a_n4158_14706# VDD VDD pfet_03v3 ad=48n pd=1.04m as=48n ps=1.04m w=400 l=1600
X17 VREF a_n4158_14706# VDD VDD pfet_03v3 ad=48n pd=1.04m as=48n ps=1.04m w=400 l=1600
X18 a_n4158_14706# a_n4958_14498# a_n7862_14706# VDD pfet_03v3 ad=44.8n pd=0.912m as=96n ps=1.84m w=800 l=800
X19 a_n6942_14706# a_n7742_14498# a_n7862_14706# VDD pfet_03v3 ad=44.8n pd=0.912m as=96n ps=1.84m w=800 l=800
X20 a_n7862_14706# a_n7742_14498# a_n6942_14706# VDD pfet_03v3 ad=96n pd=1.84m as=44.8n ps=0.912m w=800 l=800
C0 a_n7862_14706# a_n6942_14706# 0.79483f
C1 a_n4158_14706# a_n4958_14498# 1.00523f
C2 a_n4158_14706# a_n7742_14498# 0.94095f
C3 VDD a_n6942_14706# 1.21314f
C4 a_n7862_14706# a_n4958_14498# 1.04067f
C5 a_n7742_14498# a_n7862_14706# 1.041f
C6 VDD a_n4958_14498# 4.98934f
C7 VDD a_n7742_14498# 5.96795f
C8 a_1820_3936# a_n2628_328# 0.01629f
C9 VREF a_n6942_14706# 0.12999f
C10 a_n4158_14706# a_n7862_14706# 1.58977f
C11 VREF a_n4958_14498# 0.02232f
C12 VREF a_n7742_14498# 0.10118f
C13 a_n4158_14706# VDD 16.4509f
C14 VREF a_n2020_3936# 0.01498f
C15 VDD a_n7862_14706# 5.90766f
C16 a_n2628_328# a_n1060_3936# 0.03756f
C17 a_n2628_328# a_n4958_14498# 0.40214f
C18 a_n2628_328# a_860_3936# 0.0245f
C19 VREF a_n4158_14706# 0.54232f
C20 a_1820_3936# a_860_3936# 0.02424f
C21 a_n4158_14706# IBIAS 0.23873f
C22 VREF a_n7862_14706# 0.24534f
C23 VREF VDD 2.0075f
C24 a_n6942_14706# a_n4958_14498# 0.19998f
C25 a_n7742_14498# a_n6942_14706# 0.72733f
C26 a_n7742_14498# a_n1060_3936# 0.31024f
C27 a_n7742_14498# a_n4958_14498# 0.65249f
C28 a_n2020_3936# a_n1060_3936# 0.43013f
C29 a_n2020_3936# a_n4958_14498# 0.034f
C30 a_860_3936# a_n1060_3936# 0.03016f
C31 a_n7742_14498# a_860_3936# 0.08308f
C32 VREF IBIAS 0.55471f
C33 a_n4158_14706# a_n6942_14706# 0.1703f
C34 IBIAS VSS 3.60152f
C35 VREF VSS 4.50586f
C36 VDD VSS 86.3344f
C37 a_1820_3936# VSS 3.36541f ; **FLOATING
C38 a_860_3936# VSS 2.38557f ; **FLOATING
C39 a_n2628_328# VSS 3.05659f ; **FLOATING
C40 a_n1060_3936# VSS 1.87937f ; **FLOATING
C41 a_n2020_3936# VSS 2.00199f ; **FLOATING
C42 a_n4158_14706# VSS 6.06152f ; **FLOATING
C43 a_n4958_14498# VSS 5.5353f ; **FLOATING
C44 a_n6942_14706# VSS 11.7157f ; **FLOATING
C45 a_n7862_14706# VSS 1.84342f ; **FLOATING
C46 a_n7742_14498# VSS 3.52301f ; **FLOATING
.ends
