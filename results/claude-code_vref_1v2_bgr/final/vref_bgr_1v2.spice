* Bandgap 1.2 V reference (gf180mcuD, 3.3 V), ports VDD VSS VREF IBIAS.
*
* VREF = VBE(Q3) + (R2/R1) * VT * ln(N), N = 8: Q1 is one 5x5 um vertical
* PNP, Q2 two 10x10 um in parallel (emitter area 8x). The OTA forces
* VA = VB, so the R1 current is PTAT; XM1..XM3 copy it into all three
* branches. R2 = 4 x 25 um ppolyf_u_1k units against R1 = 10 um, chosen at
* the TC minimum by `mbg measure vref` (R2 unit swept 21..26 um).
* OTA: PMOS input pair (inputs sit at VBE ~ 0.7 V), NMOS mirror load, tail
* biased from PG. The core PMOS are long (L=8u) so PG sits inside the OTA's
* output range. Startup: the IBIAS current pulls the IBIAS node up while
* VREF is low, turning XM10 on to pull PG down; once VREF is up, XM9 sinks
* IBIAS and XM10 is off — VREF is then independent of IBIAS (0.01 mV over
* 5..40 uA, all corners; a W=2u XM9 let XM10 turn back on at ss/sf, 30 uA).
.subckt vref_bgr_1v2 VDD VSS VREF IBIAS
XM1 VA PG VDD VDD pfet_03v3 L=8u W=2u nf=1
XM2 VB PG VDD VDD pfet_03v3 L=8u W=2u nf=1
XM3 VREF PG VDD VDD pfet_03v3 L=8u W=2u nf=1
XQ1 VSS VSS VA pnp_05p00x05p00
XQ2a VSS VSS VX pnp_10p00x10p00
XQ2b VSS VSS VX pnp_10p00x10p00
XQ3 VSS VSS VC pnp_05p00x05p00
XR1 VB VX VSS ppolyf_u_1k r_width=1u r_length=10u
XR2a VREF n1 VSS ppolyf_u_1k r_width=1u r_length=25u
XR2b n1 n2 VSS ppolyf_u_1k r_width=1u r_length=25u
XR2c n2 n3 VSS ppolyf_u_1k r_width=1u r_length=25u
XR2d n3 VC VSS ppolyf_u_1k r_width=1u r_length=25u
XM4 NT PG VDD VDD pfet_03v3 L=8u W=2u nf=1
XM5 NM VB NT VDD pfet_03v3 L=4u W=8u nf=2
XM6 PG VA NT VDD pfet_03v3 L=4u W=8u nf=2
XM7 NM NM VSS VSS nfet_03v3 L=8u W=2u nf=1
XM8 PG NM VSS VSS nfet_03v3 L=8u W=2u nf=1
XM9 IBIAS VREF VSS VSS nfet_03v3 L=1u W=8u nf=1
XM10 PG IBIAS VSS VSS nfet_03v3 L=2u W=1u nf=1
.ends
